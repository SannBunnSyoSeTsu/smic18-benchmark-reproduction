simulator lang=spectre
global 0
include "/home/IC/Tech/smic_018mmrf-OA/SMIC_018_MMRF/models/spectre/ms018_v1p7_spe.lib" section=tt
include "/home/IC/Tech/smic_018mmrf-OA/SMIC_018_MMRF/models/spectre/ms018_v1p7_spe.lib" section=res_tt
include "/home/IC/Tech/smic_018mmrf-OA/SMIC_018_MMRF/models/spectre/ms018_v1p7_spe.lib" section=mim_tt
include "/home/IC/CodeX/smic18_benchmark_repro/runs/23/20260922T085318058247Z_output_resistance_refined/inputs/hd_cells.scs"
include "/home/IC/CodeX/smic18_benchmark_repro/runs/23/20260922T085318058247Z_output_resistance_refined/inputs/circuit.scs"
simulatorOptions options temp=27 tnom=27 reltol=2e-6 vabstol=1e-8 iabstol=1e-14
saveOptions options save=selected
subckt dac_bit_driver (cmd bit vdrv vss)
X0 (cmd n1 vdrv vss vdrv vss) INHDV3
X1 (n1 bit vdrv vss vdrv vss) INHDV32
ends dac_bit_driver
VDD (vdd 0) vsource dc=1.8
VDRV (vdrv 0) vsource dc=1.8
VC0 (c0 0) vsource type=pwl wave=[0 0 59.975n 0 60.025n 1.8 89.975n 1.8 90.025n 0 149.975n 0 150.025n 1.8]
VC1 (c1 0) vsource type=pwl wave=[0 0 59.975n 0 60.025n 1.8 89.975n 1.8 90.025n 0 149.975n 0 150.025n 1.8]
VC2 (c2 0) vsource type=pwl wave=[0 0 29.975n 0 30.025n 1.8 89.975n 1.8 90.025n 0 119.975n 0 120.025n 1.8]
VC3 (c3 0) vsource type=pwl wave=[0 0 59.975n 0 60.025n 1.8 89.975n 1.8 90.025n 0 119.975n 0 120.025n 1.8]
VC4 (c4 0) vsource type=pwl wave=[0 0 89.975n 0 90.025n 1.8]
IINJECT0 (0 vout) isource type=pwl wave=[0 0 14.975n 0 15.025n 5u 29.975n 5u 30.025n 0]
ILOAD (vout 0) isource type=pwl wave=[0 0 44.975n 0 45.025n 5u 59.975n 5u 60.025n 0 74.975n 0 75.025n 5u 89.975n 5u 90.025n 0 104.975n 0 105.025n 5u 119.975n 5u 120.025n 0 134.975n 0 135.025n 5u 149.975n 5u 150.025n 0 164.975n 0 165.025n 5u]
XDB0 (c0 b0 vdrv 0) dac_bit_driver
XDB1 (c1 b1 vdrv 0) dac_bit_driver
XDB2 (c2 b2 vdrv 0) dac_bit_driver
XDB3 (c3 b3 vdrv 0) dac_bit_driver
XDB4 (c4 b4 vdrv 0) dac_bit_driver
XDAC (0 b0 b1 b2 b3 b4 vdd vout) switched_resistor_dac_5bit
CL (vout 0) capacitor c=1p
save vout VDD:p VDRV:p c0 b0 XDAC.nb0 XDAC.sw0 c1 b1 XDAC.nb1 XDAC.sw1 c2 b2 XDAC.nb2 XDAC.sw2 c3 b3 XDAC.nb3 XDAC.sw3 c4 b4 XDAC.nb4 XDAC.sw4
tran tran stop=180n maxstep=5p skipdc=yes errpreset=conservative
