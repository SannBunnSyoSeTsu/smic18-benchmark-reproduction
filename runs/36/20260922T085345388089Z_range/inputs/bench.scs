simulator lang=spectre
global 0
include "/home/IC/Tech/smic_018mmrf-OA/SMIC_018_MMRF/models/spectre/ms018_v1p7_spe.lib" section=tt
include "/home/IC/CodeX/smic18_benchmark_repro/runs/36/20260922T085345388089Z_range/inputs/circuit.scs"
simulatorOptions options temp=27 tnom=27 reltol=1e-6 vabstol=1e-9 iabstol=1e-15
saveOptions options save=selected
VDD (vdd 0) vsource dc=1.8
IREF (vdd iref) isource dc=50u
X (0 iref vdd vinn vinp vocm voutn voutp) telescopic_cascode_ota
CLP (voutp 0) capacitor c=2p
CLN (voutn 0) capacitor c=2p
save voutp voutn VDD:p vocm vinn vinp iref
parameters command=0
VOCM (vocm 0) vsource dc=.9
VERR (err0 0) vsource dc=command
EFB (err err0 voutp voutn) vcvs gain=-1
EINP (vinp vocm err 0) vcvs gain=.5
EINN (vinn vocm err 0) vcvs gain=-.5
save err0 err
swing dc param=command start=-.45 stop=.45 step=.005
