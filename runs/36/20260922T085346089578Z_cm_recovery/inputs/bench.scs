simulator lang=spectre
global 0
include "/home/IC/Tech/smic_018mmrf-OA/SMIC_018_MMRF/models/spectre/ms018_v1p7_spe.lib" section=tt
include "/home/IC/CodeX/smic18_benchmark_repro/runs/36/20260922T085346089578Z_cm_recovery/inputs/circuit.scs"
simulatorOptions options temp=27 tnom=27 reltol=1e-6 vabstol=1e-9 iabstol=1e-15
saveOptions options save=selected
VDD (vdd 0) vsource dc=1.8
IREF (vdd iref) isource dc=50u
X (0 iref vdd vinn vinp vocm voutn voutp) telescopic_cascode_ota
CLP (voutp 0) capacitor c=2p
CLN (voutn 0) capacitor c=2p
save voutp voutn VDD:p vocm vinn vinp iref
VOCM (vocm 0) vsource type=pwl wave=[0 .85 20n .85 21n .95 160n .95]
VINP (vinp 0) vsource dc=.9
VINN (vinn 0) vsource dc=.9
save X.vctrl X.vcm_sense X.vcn X.vbpc
tran tran stop=160n maxstep=25p strobeperiod=50p strobeoutput=strobeonly errpreset=conservative
