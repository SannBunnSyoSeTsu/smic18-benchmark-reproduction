simulator lang=spectre
global 0
include "/home/IC/Tech/smic_018mmrf-OA/SMIC_018_MMRF/models/spectre/ms018_v1p7_spe.lib" section=tt
include "/home/IC/CodeX/smic18_benchmark_repro/runs/36/20260922T085345536109Z_settling/inputs/circuit.scs"
simulatorOptions options temp=27 tnom=27 reltol=1e-6 vabstol=1e-9 iabstol=1e-15
saveOptions options save=selected
VDD (vdd 0) vsource dc=1.8
IREF (vdd iref) isource dc=50u
X (0 iref vdd vinn vinp vocm voutn voutp) telescopic_cascode_ota
CLP (voutp 0) capacitor c=2p
CLN (voutn 0) capacitor c=2p
save voutp voutn VDD:p vocm vinn vinp iref
VOCM (vocm 0) vsource dc=.9
VERR (err0 0) vsource type=pwl wave=[0 -.05 20n -.05 21n .05 140n .05]
EFB (err err0 voutp voutn) vcvs gain=-1
EINP (vinp vocm err 0) vcvs gain=.5
EINN (vinn vocm err 0) vcvs gain=-.5
save err0 err
tran tran stop=140n maxstep=25p strobeperiod=50p strobeoutput=strobeonly errpreset=conservative
