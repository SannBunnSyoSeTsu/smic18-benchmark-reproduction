simulator lang=spectre
global 0
include "/home/IC/Tech/smic_018mmrf-OA/SMIC_018_MMRF/models/spectre/ms018_v1p7_spe.lib" section=tt
include "/home/IC/CodeX/smic18_benchmark_repro/runs/36/20260922T085423643569Z_cmstb/inputs/cmprobe.scs"
simulatorOptions options temp=27 tnom=27 reltol=1e-6 vabstol=1e-9 iabstol=1e-15
saveOptions options save=selected
VDD (vdd 0) vsource dc=1.8
IREF (vdd iref) isource dc=50u
X (0 iref vdd vinn vinp vocm voutn voutp) telescopic_cascode_ota
CLP (voutp 0) capacitor c=2p
CLN (voutn 0) capacitor c=2p
save voutp voutn VDD:p vocm vinn vinp iref
VOCM (vocm 0) vsource dc=.9
VINP (vinp 0) vsource dc=.9 mag=.5
VINN (vinn 0) vsource dc=.9 mag=.5 phase=180
save X.tail X.a1 X.a2 X.pn X.pp X.vcn X.vbpc X.vctrl X.srep X.x1 X.x2 X.vbp X.cmt X.dg X.vcm_sense
save X.MREF:ids X.MREF:gm X.MREF:gds X.MREF:vgs X.MREF:vds X.MREF:vdsat X.MREF:region
save X.MTAIL:ids X.MTAIL:gm X.MTAIL:gds X.MTAIL:vgs X.MTAIL:vds X.MTAIL:vdsat X.MTAIL:region
save X.MINP:ids X.MINP:gm X.MINP:gds X.MINP:vgs X.MINP:vds X.MINP:vdsat X.MINP:region
save X.MINN:ids X.MINN:gm X.MINN:gds X.MINN:vgs X.MINN:vds X.MINN:vdsat X.MINN:region
save X.MNCP:ids X.MNCP:gm X.MNCP:gds X.MNCP:vgs X.MNCP:vds X.MNCP:vdsat X.MNCP:region
save X.MNCN:ids X.MNCN:gm X.MNCN:gds X.MNCN:vgs X.MNCN:vds X.MNCN:vdsat X.MNCN:region
save X.MPCN:ids X.MPCN:gm X.MPCN:gds X.MPCN:vgs X.MPCN:vds X.MPCN:vdsat X.MPCN:region
save X.MPCP:ids X.MPCP:gm X.MPCP:gds X.MPCP:vgs X.MPCP:vds X.MPCP:vdsat X.MPCP:region
save X.MPTN:ids X.MPTN:gm X.MPTN:gds X.MPTN:vgs X.MPTN:vds X.MPTN:vdsat X.MPTN:region
save X.MPTP:ids X.MPTP:gm X.MPTP:gds X.MPTP:vgs X.MPTP:vds X.MPTP:vdsat X.MPTP:region
save X.MR1:ids X.MR1:gm X.MR1:gds X.MR1:vgs X.MR1:vds X.MR1:vdsat X.MR1:region
save X.MT1:ids X.MT1:gm X.MT1:gds X.MT1:vgs X.MT1:vds X.MT1:vdsat X.MT1:region
save X.MPB2:ids X.MPB2:gm X.MPB2:gds X.MPB2:vgs X.MPB2:vds X.MPB2:vdsat X.MPB2:region
save X.MD1:ids X.MD1:gm X.MD1:gds X.MD1:vgs X.MD1:vds X.MD1:vdsat X.MD1:region
save X.MDP1:ids X.MDP1:gm X.MDP1:gds X.MDP1:vgs X.MDP1:vds X.MDP1:vdsat X.MDP1:region
save X.MT4:ids X.MT4:gm X.MT4:gds X.MT4:vgs X.MT4:vds X.MT4:vdsat X.MT4:region
save X.MPM:ids X.MPM:gm X.MPM:gds X.MPM:vgs X.MPM:vds X.MPM:vdsat X.MPM:region
save X.MT5:ids X.MT5:gm X.MT5:gds X.MT5:vgs X.MT5:vds X.MT5:vdsat X.MT5:region
save X.MCMS:ids X.MCMS:gm X.MCMS:gds X.MCMS:vgs X.MCMS:vds X.MCMS:vdsat X.MCMS:region
save X.MCMR:ids X.MCMR:gm X.MCMR:gds X.MCMR:vgs X.MCMR:vds X.MCMR:vdsat X.MCMR:region
save X.MCMT:ids X.MCMT:gm X.MCMT:gds X.MCMT:vgs X.MCMT:vds X.MCMT:vdsat X.MCMT:region
save X.MCML:ids X.MCML:gm X.MCML:gds X.MCML:vgs X.MCML:vds X.MCML:vdsat X.MCML:region
save X.MCMLO:ids X.MCMLO:gm X.MCMLO:gds X.MCMLO:vgs X.MCMLO:vds X.MCMLO:vdsat X.MCMLO:region
dcOp dc
cmstb stb start=1 stop=10G dec=100 probe=X.PCM
