simulator lang=spectre
global 0
include "/home/IC/Tech/smic_018mmrf-OA/SMIC_018_MMRF/models/spectre/ms018_v1p7_spe.lib" section=tt
include "/home/IC/CodeX/smic18_benchmark_repro/runs/34/20260926T051253347871Z_settling/inputs/circuit.scs"
simulatorOptions options temp=27 tnom=27 reltol=1e-6 vabstol=1e-10 iabstol=1e-15
saveOptions options save=selected
VSS (vss 0) vsource dc=0
VDD (vdd vss) vsource dc=1.8
IREF (vdd iref) isource dc=50u
VOCM (vocm vss) vsource dc=.9
X (vss iref vdd vinn vinp vocm voutn voutp) sampling_feedback_ota
CLP (voutp vss) capacitor c=0.25p
CLN (voutn vss) capacitor c=0.25p
save vdd vss iref vocm vinp vinn voutp voutn VDD:p
VSIGP (srcp vss) vsource type=pulse val0=.9 val1=.95625 delay=25n rise=50p fall=50p width=40n period=100n
VSIGN (srcn vss) vsource type=pulse val0=.9 val1=.84375 delay=25n rise=50p fall=50p width=40n period=100n
CSP (srcp vinp) capacitor c=1p
CSN (srcn vinn) capacitor c=1p
CFP (voutn vinp) capacitor c=125f
CFN (voutp vinn) capacitor c=125f
LBP (vocm vinp) inductor l=1G
LBN (vocm vinn) inductor l=1G
save srcp srcn
save X.stagep X.stagen X.vcmfb X.vcms
tran tran stop=105n maxstep=10p errpreset=conservative method=gear2only
