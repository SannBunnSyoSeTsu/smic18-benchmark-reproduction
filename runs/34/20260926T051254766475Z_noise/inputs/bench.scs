simulator lang=spectre
global 0
include "/home/IC/Tech/smic_018mmrf-OA/SMIC_018_MMRF/models/spectre/ms018_v1p7_spe.lib" section=tt
include "/home/IC/CodeX/smic18_benchmark_repro/runs/34/20260926T051254766475Z_noise/inputs/circuit.scs"
simulatorOptions options temp=27 tnom=27 reltol=1e-6 vabstol=1e-10 iabstol=1e-15
saveOptions options save=selected
VSS (vss 0) vsource dc=0
VDD (vdd vss) vsource dc=1.8
IREF (vdd iref) isource dc=50u
VOCM (vocm vss) vsource dc=.9
X (vss iref vdd vinn vinp vocm voutn voutp) sampling_feedback_ota
CLP (voutp vss) capacitor c=0.25p
CLN (voutn vss) capacitor c=0.25p
save vdd vss iref vocm vinp vinn voutp voutn VDD:p
VNOISE (srcp vss) vsource dc=.9 mag=1
VQUIET (srcn vss) vsource dc=.9
CSP (srcp vinp) capacitor c=1p
CSN (srcn vinn) capacitor c=1p
CFP (voutn vinp) capacitor c=125f
CFN (voutp vinn) capacitor c=125f
LBP (vocm vinp) inductor l=1G
LBN (vocm vinn) inductor l=1G
save srcp srcn
noise (voutp voutn) noise iprobe=VNOISE start=10 stop=10G dec=80
