simulator lang=spectre
include "/home/IC/Tech/smic_018mmrf-OA/SMIC_018_MMRF/models/spectre/ms018_v1p7_spe.lib" section=tt
include "/home/IC/CodeX/smic18_benchmark_repro/runs/08/20260922T103900239843Z_tran11M/inputs/circuit.scs"
simulatorOptions options temp=27 tnom=27 reltol=1e-6 vabstol=1e-9 iabstol=1e-14
VDD (vdd 0) vsource dc=1.8
VCM (vcm 0) vsource dc=.9
IREF (vdd iref) isource dc=20u
X (iref vcm vdd vin vip von vop 0) buf_ppsf_bs
CLP (vop 0) capacitor c=1p
CLN (von 0) capacitor c=1p
save vop von vip vin VDD:p VCM:p VIP:p VIN:p X.VBN1 X.VBN2 X.VBP1 X.VBP2 X.ndP X.pdP
VIP (vip 0) vsource dc=.9 type=sine sinedc=0 ampl=.4 freq=1.1e+07 sinephase=0
VIN (vin 0) vsource dc=.9 type=sine sinedc=0 ampl=.4 freq=1.1e+07 sinephase=180
tran tran stop=50u maxstep=100p strobeperiod=1n strobeoutput=strobeonly errpreset=conservative
