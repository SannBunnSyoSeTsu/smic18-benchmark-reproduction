simulator lang=spectre
global 0
parameters vddval=1.8
include "/home/IC/Tech/smic_018mmrf-OA/SMIC_018_MMRF/models/spectre/ms018_v1p7_spe.lib" section=tt
include "/home/IC/Tech/smic_018mmrf-OA/SMIC_018_MMRF/models/spectre/ms018_v1p7_spe.lib" section=bjt_tt
include "/home/IC/Tech/smic_018mmrf-OA/SMIC_018_MMRF/models/spectre/ms018_v1p7_spe.lib" section=res_tt
include "/home/IC/Tech/smic_018mmrf-OA/SMIC_018_MMRF/models/spectre/ms018_v1p7_spe.lib" section=mim_tt
include "/home/IC/CodeX/smic18_benchmark_repro/runs/11/20260926T020534268332Z_step/inputs/circuit.scs"
VDD (vdd 0) vsource type=pwl wave=[0 1.8 5u 1.8 5.01u 1.98 15u 1.98 15.01u 1.62 30u 1.62]
X (0 vdd vref) bandgap_reference
CLOAD (vref 0) capacitor c=5p
simulatorOptions options temp=27 tnom=27 reltol=1e-6 vabstol=1e-9 iabstol=1e-15
saveOptions options save=selected
save vdd vref VDD:p X.va X.vb X.n1 X.vctat X.pctrl X.nout X.nbias X.tail X.st
tran tran stop=30u maxstep=1n strobeperiod=1n strobeoutput=strobeonly errpreset=conservative
