simulator lang=spectre
global 0
parameters vddval=1.8
include "/home/IC/Tech/smic_018mmrf-OA/SMIC_018_MMRF/models/spectre/ms018_v1p7_spe.lib" section=tt
include "/home/IC/Tech/smic_018mmrf-OA/SMIC_018_MMRF/models/spectre/ms018_v1p7_spe.lib" section=bjt_tt
include "/home/IC/Tech/smic_018mmrf-OA/SMIC_018_MMRF/models/spectre/ms018_v1p7_spe.lib" section=res_tt
include "/home/IC/Tech/smic_018mmrf-OA/SMIC_018_MMRF/models/spectre/ms018_v1p7_spe.lib" section=mim_tt
include "/home/IC/CodeX/smic18_benchmark_repro/runs/11/20260926T020742387816Z_static/inputs/circuit.scs"
VDD (vdd 0) vsource dc=vddval mag=1
X (0 vdd vref) bandgap_reference
CLOAD (vref 0) capacitor c=5p
simulatorOptions options temp=27 tnom=27 reltol=1e-6 vabstol=1e-9 iabstol=1e-15
saveOptions options save=selected
save vdd vref VDD:p X.va X.vb X.n1 X.vctat X.pctrl X.nout X.nbias X.tail X.st
save X.MP0:ids X.MP0:gm X.MP0:gds X.MP0:vgs X.MP0:vds X.MP0:vbs X.MP0:vdsat X.MP0:region
save X.MP1:ids X.MP1:gm X.MP1:gds X.MP1:vgs X.MP1:vds X.MP1:vbs X.MP1:vdsat X.MP1:region
save X.MP2:ids X.MP2:gm X.MP2:gds X.MP2:vgs X.MP2:vds X.MP2:vbs X.MP2:vdsat X.MP2:region
save X.MNB:ids X.MNB:gm X.MNB:gds X.MNB:vgs X.MNB:vds X.MNB:vbs X.MNB:vdsat X.MNB:region
save X.MTAIL:ids X.MTAIL:gm X.MTAIL:gds X.MTAIL:vgs X.MTAIL:vds X.MTAIL:vbs X.MTAIL:vdsat X.MTAIL:region
save X.MINA:ids X.MINA:gm X.MINA:gds X.MINA:vgs X.MINA:vds X.MINA:vbs X.MINA:vdsat X.MINA:region
save X.MINB:ids X.MINB:gm X.MINB:gds X.MINB:vgs X.MINB:vds X.MINB:vbs X.MINB:vdsat X.MINB:region
save X.MPD:ids X.MPD:gm X.MPD:gds X.MPD:vgs X.MPD:vds X.MPD:vbs X.MPD:vdsat X.MPD:region
save X.MPM:ids X.MPM:gm X.MPM:gds X.MPM:vgs X.MPM:vds X.MPM:vbs X.MPM:vdsat X.MPM:region
save X.MPST:ids X.MPST:gm X.MPST:gds X.MPST:vgs X.MPST:vds X.MPST:vbs X.MPST:vdsat X.MPST:region
save X.MNST:ids X.MNST:gm X.MNST:gds X.MNST:vgs X.MNST:vds X.MNST:vbs X.MNST:vdsat X.MNST:region
save X.MSTART:ids X.MSTART:gm X.MSTART:gds X.MSTART:vgs X.MSTART:vds X.MSTART:vbs X.MSTART:vdsat X.MSTART:region
dcOp dc
line dc param=vddval values=[1.62 1.8 1.98]
temperature dc param=temp values=[-40 0 27 60 100 125]
