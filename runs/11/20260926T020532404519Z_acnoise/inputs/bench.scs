simulator lang=spectre
global 0
parameters vddval=1.8
include "/home/IC/Tech/smic_018mmrf-OA/SMIC_018_MMRF/models/spectre/ms018_v1p7_spe.lib" section=tt
include "/home/IC/Tech/smic_018mmrf-OA/SMIC_018_MMRF/models/spectre/ms018_v1p7_spe.lib" section=bjt_tt
include "/home/IC/Tech/smic_018mmrf-OA/SMIC_018_MMRF/models/spectre/ms018_v1p7_spe.lib" section=res_tt
include "/home/IC/Tech/smic_018mmrf-OA/SMIC_018_MMRF/models/spectre/ms018_v1p7_spe.lib" section=mim_tt
include "/home/IC/CodeX/smic18_benchmark_repro/runs/11/20260926T020532404519Z_acnoise/inputs/circuit.scs"
VDD (vdd 0) vsource dc=vddval mag=1
X (0 vdd vref) bandgap_reference
CLOAD (vref 0) capacitor c=5p
simulatorOptions options temp=27 tnom=27 reltol=1e-6 vabstol=1e-9 iabstol=1e-15
saveOptions options save=selected
save vdd vref VDD:p X.va X.vb X.n1 X.vctat X.pctrl X.nout X.nbias X.tail X.st
dcOp dc
ac ac start=10 stop=100M dec=100
noise (vref 0) noise start=10 stop=1M dec=100 iprobe=VDD
