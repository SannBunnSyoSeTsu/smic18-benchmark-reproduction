simulator lang=spectre
global 0
parameters vddval=1.8
include "/home/IC/Tech/smic_018mmrf-OA/SMIC_018_MMRF/models/spectre/ms018_v1p7_spe.lib" section=tt
include "/home/IC/Tech/smic_018mmrf-OA/SMIC_018_MMRF/models/spectre/ms018_v1p7_spe.lib" section=bjt_tt
include "/home/IC/Tech/smic_018mmrf-OA/SMIC_018_MMRF/models/spectre/ms018_v1p7_spe.lib" section=res_tt
include "/home/IC/Tech/smic_018mmrf-OA/SMIC_018_MMRF/models/spectre/ms018_v1p7_spe.lib" section=mim_tt
include "/home/IC/CodeX/smic18_benchmark_repro/runs/11/20260926T020533129366Z_startup1/inputs/circuit.scs"
VDD (vdd 0) vsource type=pwl wave=[0 0 1e-06 1.8 2.1e-05 1.8]
X (0 vdd vref) bandgap_reference
CLOAD (vref 0) capacitor c=5p
simulatorOptions options temp=27 tnom=27 reltol=1e-6 vabstol=1e-9 iabstol=1e-15
saveOptions options save=selected
save vdd vref VDD:p X.va X.vb X.n1 X.vctat X.pctrl X.nout X.nbias X.tail X.st
ic vref=0 X.va=0 X.vb=0 X.n1=0 X.vctat=0 X.pctrl=0 X.nout=0 X.nbias=0 X.tail=0 X.st=0
tran tran stop=2.1e-05 maxstep=2n strobeperiod=2n strobeoutput=strobeonly skipdc=yes errpreset=conservative
