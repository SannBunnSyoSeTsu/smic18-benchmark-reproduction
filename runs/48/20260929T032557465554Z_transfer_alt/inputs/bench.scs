simulator lang=spectre
global 0
include "/home/IC/Tech/smic_018mmrf-OA/SMIC_018_MMRF/models/spectre/ms018_v1p7_spe.lib" section=tt
include "/home/IC/CodeX/smic18_benchmark_repro/runs/48/20260929T032557465554Z_transfer_alt/inputs/hd_cells.scs"
include "/home/IC/CodeX/smic18_benchmark_repro/runs/48/20260929T032557465554Z_transfer_alt/inputs/circuit.scs"
VDD (vdd 0) vsource dc=1.8
VREFP (vrefp 0) vsource dc=1.8
VCLKS (clks_src 0) vsource type=pulse val0=0 val1=1.8 delay=1p rise=20p fall=20p width=1.98n period=10n
RCLKS (clks_src clks) resistor r=50
X (clks d3 d2 d1 d0 0 vdd vinn vinp 0 vrefp) sar_adc_4bit_async
simulatorOptions options temp=27 tnom=27 reltol=1e-06 vabstol=1e-8 iabstol=1e-14 gmin=1e-15
saveOptions options save=selected
save clks_src clks vinp vinn vcm d0 d1 d2 d3 VDD:p VREFP:p VINP:p VINN:p VCLKS:p
C0 (d0 0) capacitor c=10f
C1 (d1 0) capacitor c=10f
C2 (d2 0) capacitor c=10f
C3 (d3 0) capacitor c=10f
VINP (vinp 0) vsource type=pwl wave=[0n 1.74375 22.2n 1.74375 22.25n 0.50625 27.5n 0.50625 27.55n 0.05625 32.2n 0.05625 32.25n 0.61875 37.5n 0.61875 37.55n 0.95625 42.2n 0.95625 42.25n 1.51875 47.5n 1.51875 47.55n 0.84375 52.2n 0.84375 52.25n 1.40625 57.5n 1.40625 57.55n 0.39375 62.2n 0.39375 62.25n 0.95625 67.5n 0.95625 67.55n 1.40625 72.2n 1.40625 72.25n 0.16875 77.5n 0.16875 77.55n 0.61875 82.2n 0.61875 82.25n 1.18125 87.5n 1.18125 87.55n 1.18125 92.2n 1.18125 92.25n 1.74375 97.5n 1.74375 97.55n 0.16875 102.2n 0.16875 102.25n 0.73125 107.5n 0.73125 107.55n 1.63125 112.2n 1.63125 112.25n 0.39375 117.5n 0.39375 117.55n 0.73125 122.2n 0.73125 122.25n 1.29375 127.5n 1.29375 127.55n 1.06875 132.2n 1.06875 132.25n 1.63125 137.5n 1.63125 137.55n 0.28125 142.2n 0.28125 142.25n 0.84375 147.5n 0.84375 147.55n 1.51875 152.2n 1.51875 152.25n 0.28125 157.5n 0.28125 157.55n 0.50625 162.2n 0.50625 162.25n 1.06875 167.5n 1.06875 167.55n 1.29375 172.2n 1.29375 172.25n 0.05625]
VINN (vinn 0) vsource type=pwl wave=[0n 0.05625 22.2n 0.05625 22.25n 1.29375 27.5n 1.29375 27.55n 1.74375 32.2n 1.74375 32.25n 1.18125 37.5n 1.18125 37.55n 0.84375 42.2n 0.84375 42.25n 0.28125 47.5n 0.28125 47.55n 0.95625 52.2n 0.95625 52.25n 0.39375 57.5n 0.39375 57.55n 1.40625 62.2n 1.40625 62.25n 0.84375 67.5n 0.84375 67.55n 0.39375 72.2n 0.39375 72.25n 1.63125 77.5n 1.63125 77.55n 1.18125 82.2n 1.18125 82.25n 0.61875 87.5n 0.61875 87.55n 0.61875 92.2n 0.61875 92.25n 0.05625 97.5n 0.05625 97.55n 1.63125 102.2n 1.63125 102.25n 1.06875 107.5n 1.06875 107.55n 0.16875 112.2n 0.16875 112.25n 1.40625 117.5n 1.40625 117.55n 1.06875 122.2n 1.06875 122.25n 0.50625 127.5n 0.50625 127.55n 0.73125 132.2n 0.73125 132.25n 0.16875 137.5n 0.16875 137.55n 1.51875 142.2n 1.51875 142.25n 0.95625 147.5n 0.95625 147.55n 0.28125 152.2n 0.28125 152.25n 1.51875 157.5n 1.51875 157.55n 1.29375 162.2n 1.29375 162.25n 0.73125 167.5n 0.73125 167.55n 0.50625 172.2n 0.50625 172.25n 1.74375]
VCM (vcm 0) vsource dc=.9
tran tran stop=1.895e-07 maxstep=2.5e-11 method=gear2only errpreset=conservative
