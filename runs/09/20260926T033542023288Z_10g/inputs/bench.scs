simulator lang=spectre
global 0
include "/home/IC/Tech/smic_018mmrf-OA/SMIC_018_MMRF/models/spectre/ms018_v1p7_spe.lib" section=tt
include "/home/IC/CodeX/smic18_benchmark_repro/runs/09/20260926T033542023288Z_10g/inputs/circuit.scs"
VDD (vdd 0) vsource dc=1.8
IREF (vdd iref) isource dc=150u
X (0 iref vdd clkn clkp outn outp) cml_div2
CLP (outp 0) capacitor c=10f
CLN (outn 0) capacitor c=10f
simulatorOptions options temp=27 tnom=27 reltol=1e-5 vabstol=1e-8 iabstol=1e-14
saveOptions options save=selected
save vdd iref clkp clkn outp outn VDD:p X.mp X.mn X.nmd X.nmr X.mtail X.nsd X.nsr X.stail
nodeset outp=1.0 outn=0.8
VCLKP (srcp 0) vsource type=pwl wave=[0f 0.825 100000f 0.825 110000f 0.975 150000f 0.975 160000f 0.825 200000f 0.825 210000f 0.975 250000f 0.975 260000f 0.825 300000f 0.825 310000f 0.975 350000f 0.975 360000f 0.825 400000f 0.825 410000f 0.975 450000f 0.975 460000f 0.825 500000f 0.825 510000f 0.975 550000f 0.975 560000f 0.825 600000f 0.825 610000f 0.975 650000f 0.975 660000f 0.825 700000f 0.825 710000f 0.975 750000f 0.975 760000f 0.825 800000f 0.825 810000f 0.975 850000f 0.975 860000f 0.825 900000f 0.825 910000f 0.975 950000f 0.975 960000f 0.825 1000000f 0.825 1010000f 0.975 1050000f 0.975 1060000f 0.825 1100000f 0.825 1110000f 0.975 1150000f 0.975 1160000f 0.825 1200000f 0.825 1210000f 0.975 1250000f 0.975 1260000f 0.825 1300000f 0.825 1310000f 0.975 1350000f 0.975 1360000f 0.825 1400000f 0.825 1410000f 0.975 1450000f 0.975 1460000f 0.825 1500000f 0.825 1510000f 0.975 1550000f 0.975 1560000f 0.825 1600000f 0.825 1610000f 0.975 1650000f 0.975 1660000f 0.825 1700000f 0.825 1710000f 0.975 1750000f 0.975 1760000f 0.825 1800000f 0.825 1810000f 0.975 1850000f 0.975 1860000f 0.825 1900000f 0.825 1910000f 0.975 1950000f 0.975 1960000f 0.825 2000000f 0.825 2010000f 0.975 2050000f 0.975 2060000f 0.825 2100000f 0.825 2110000f 0.975 2150000f 0.975 2160000f 0.825 2200000f 0.825 2210000f 0.975 2250000f 0.975 2260000f 0.825 2300000f 0.825 2310000f 0.975 2350000f 0.975 2360000f 0.825 2400000f 0.825 2410000f 0.975 2450000f 0.975 2460000f 0.825 2500000f 0.825 2510000f 0.975 2550000f 0.975 2560000f 0.825 2600000f 0.825 2610000f 0.975 2650000f 0.975 2660000f 0.825 2700000f 0.825 2710000f 0.975 2750000f 0.975 2760000f 0.825 2800000f 0.825 2810000f 0.975 2850000f 0.975 2860000f 0.825 2900000f 0.825 2910000f 0.975 2950000f 0.975 2960000f 0.825 3000000f 0.825 3010000f 0.975 3050000f 0.975 3060000f 0.825 3100000f 0.825 3110000f 0.975 3150000f 0.975 3160000f 0.825 3200000f 0.825 3210000f 0.975 3250000f 0.975 3260000f 0.825 3300000f 0.825 3310000f 0.975 3350000f 0.975 3360000f 0.825 3400000f 0.825 3410000f 0.975 3450000f 0.975 3460000f 0.825 3500000f 0.825 3510000f 0.975 3550000f 0.975 3560000f 0.825 3600000f 0.825 3610000f 0.975 3650000f 0.975 3660000f 0.825 3700000f 0.825 3710000f 0.975 3750000f 0.975 3760000f 0.825 3800000f 0.825 3810000f 0.975 3850000f 0.975 3860000f 0.825 3900000f 0.825 3910000f 0.975 3950000f 0.975 3960000f 0.825 4000000f 0.825 4010000f 0.975 4050000f 0.975 4060000f 0.825 4100000f 0.825 4110000f 0.975 4150000f 0.975 4160000f 0.825 4200000f 0.825 4210000f 0.975 4250000f 0.975 4260000f 0.825 4300000f 0.825 4310000f 0.975 4350000f 0.975 4360000f 0.825 4400000f 0.825 4410000f 0.975 4450000f 0.975 4460000f 0.825 4500000f 0.825 4510000f 0.975 4550000f 0.975 4560000f 0.825 4600000f 0.825 4610000f 0.975 4650000f 0.975 4660000f 0.825 4700000f 0.825 4710000f 0.975 4750000f 0.975 4760000f 0.825 4800000f 0.825 4810000f 0.975 4850000f 0.975 4860000f 0.825 4900000f 0.825 4910000f 0.975 4950000f 0.975 4960000f 0.825 5000000f 0.825 5010000f 0.975 5050000f 0.975 5060000f 0.825 5100000f 0.825 5110000f 0.975 5150000f 0.975 5160000f 0.825 5200000f 0.825 5210000f 0.975 5250000f 0.975 5260000f 0.825 5300000f 0.825 5310000f 0.975 5350000f 0.975 5360000f 0.825 5400000f 0.825 5410000f 0.975 5450000f 0.975 5460000f 0.825 5500000f 0.825 5510000f 0.975 5550000f 0.975 5560000f 0.825 5600000f 0.825 5610000f 0.975 5650000f 0.975 5660000f 0.825 5700000f 0.825 5710000f 0.975 5750000f 0.975 5760000f 0.825 5800000f 0.825 5810000f 0.975 5850000f 0.975 5860000f 0.825 5900000f 0.825 5910000f 0.975 5950000f 0.975 5960000f 0.825 6000000f 0.825 6010000f 0.975 6050000f 0.975 6060000f 0.825 6100000f 0.825 6110000f 0.975 6150000f 0.975 6160000f 0.825 6200000f 0.825 6210000f 0.975 6250000f 0.975 6260000f 0.825 6300000f 0.825 6310000f 0.975 6350000f 0.975 6360000f 0.825 6400000f 0.825 6410000f 0.975 6450000f 0.975 6460000f 0.825 6500000f 0.825 6510000f 0.975 6550000f 0.975 6560000f 0.825 6600000f 0.825 6610000f 0.975 6650000f 0.975 6660000f 0.825 6700000f 0.825 6710000f 0.975 6750000f 0.975 6760000f 0.825 6800000f 0.825 6810000f 0.975 6850000f 0.975 6860000f 0.825 6900000f 0.825 6910000f 0.975 6950000f 0.975 6960000f 0.825 7000000f 0.825 7010000f 0.975 7050000f 0.975 7060000f 0.825 7100000f 0.825 7110000f 0.975 7150000f 0.975 7160000f 0.825 7200000f 0.825 7210000f 0.975 7250000f 0.975 7260000f 0.825 7300000f 0.825 7310000f 0.975 7350000f 0.975 7360000f 0.825 7400000f 0.825 7410000f 0.975 7450000f 0.975 7460000f 0.825 7500000f 0.825 7510000f 0.975 7550000f 0.975 7560000f 0.825 7600000f 0.825 7610000f 0.975 7650000f 0.975 7660000f 0.825 7700000f 0.825 7710000f 0.975 7750000f 0.975 7760000f 0.825 7800000f 0.825 7810000f 0.975 7850000f 0.975 7860000f 0.825 7900000f 0.825 7910000f 0.975 7950000f 0.975 7960000f 0.825 8000000f 0.825 8010000f 0.975 8050000f 0.975 8060000f 0.825 8100000f 0.825 8110000f 0.975 8150000f 0.975 8160000f 0.825 8200000f 0.825 8210000f 0.975 8250000f 0.975 8260000f 0.825 8300000f 0.825 8310000f 0.975 8350000f 0.975 8360000f 0.825 8400000f 0.825 8410000f 0.975 8450000f 0.975 8460000f 0.825 8500000f 0.825 8510000f 0.975 8550000f 0.975 8560000f 0.825 8600000f 0.825 8610000f 0.975 8650000f 0.975 8660000f 0.825 8700000f 0.825 8710000f 0.975 8750000f 0.975 8760000f 0.825 8800000f 0.825 8810000f 0.975 8850000f 0.975 8860000f 0.825 8900000f 0.825 8910000f 0.975 8950000f 0.975 8960000f 0.825 9000000f 0.825]
VCLKN (srcn 0) vsource type=pwl wave=[0f 0.975 100000f 0.975 110000f 0.825 150000f 0.825 160000f 0.975 200000f 0.975 210000f 0.825 250000f 0.825 260000f 0.975 300000f 0.975 310000f 0.825 350000f 0.825 360000f 0.975 400000f 0.975 410000f 0.825 450000f 0.825 460000f 0.975 500000f 0.975 510000f 0.825 550000f 0.825 560000f 0.975 600000f 0.975 610000f 0.825 650000f 0.825 660000f 0.975 700000f 0.975 710000f 0.825 750000f 0.825 760000f 0.975 800000f 0.975 810000f 0.825 850000f 0.825 860000f 0.975 900000f 0.975 910000f 0.825 950000f 0.825 960000f 0.975 1000000f 0.975 1010000f 0.825 1050000f 0.825 1060000f 0.975 1100000f 0.975 1110000f 0.825 1150000f 0.825 1160000f 0.975 1200000f 0.975 1210000f 0.825 1250000f 0.825 1260000f 0.975 1300000f 0.975 1310000f 0.825 1350000f 0.825 1360000f 0.975 1400000f 0.975 1410000f 0.825 1450000f 0.825 1460000f 0.975 1500000f 0.975 1510000f 0.825 1550000f 0.825 1560000f 0.975 1600000f 0.975 1610000f 0.825 1650000f 0.825 1660000f 0.975 1700000f 0.975 1710000f 0.825 1750000f 0.825 1760000f 0.975 1800000f 0.975 1810000f 0.825 1850000f 0.825 1860000f 0.975 1900000f 0.975 1910000f 0.825 1950000f 0.825 1960000f 0.975 2000000f 0.975 2010000f 0.825 2050000f 0.825 2060000f 0.975 2100000f 0.975 2110000f 0.825 2150000f 0.825 2160000f 0.975 2200000f 0.975 2210000f 0.825 2250000f 0.825 2260000f 0.975 2300000f 0.975 2310000f 0.825 2350000f 0.825 2360000f 0.975 2400000f 0.975 2410000f 0.825 2450000f 0.825 2460000f 0.975 2500000f 0.975 2510000f 0.825 2550000f 0.825 2560000f 0.975 2600000f 0.975 2610000f 0.825 2650000f 0.825 2660000f 0.975 2700000f 0.975 2710000f 0.825 2750000f 0.825 2760000f 0.975 2800000f 0.975 2810000f 0.825 2850000f 0.825 2860000f 0.975 2900000f 0.975 2910000f 0.825 2950000f 0.825 2960000f 0.975 3000000f 0.975 3010000f 0.825 3050000f 0.825 3060000f 0.975 3100000f 0.975 3110000f 0.825 3150000f 0.825 3160000f 0.975 3200000f 0.975 3210000f 0.825 3250000f 0.825 3260000f 0.975 3300000f 0.975 3310000f 0.825 3350000f 0.825 3360000f 0.975 3400000f 0.975 3410000f 0.825 3450000f 0.825 3460000f 0.975 3500000f 0.975 3510000f 0.825 3550000f 0.825 3560000f 0.975 3600000f 0.975 3610000f 0.825 3650000f 0.825 3660000f 0.975 3700000f 0.975 3710000f 0.825 3750000f 0.825 3760000f 0.975 3800000f 0.975 3810000f 0.825 3850000f 0.825 3860000f 0.975 3900000f 0.975 3910000f 0.825 3950000f 0.825 3960000f 0.975 4000000f 0.975 4010000f 0.825 4050000f 0.825 4060000f 0.975 4100000f 0.975 4110000f 0.825 4150000f 0.825 4160000f 0.975 4200000f 0.975 4210000f 0.825 4250000f 0.825 4260000f 0.975 4300000f 0.975 4310000f 0.825 4350000f 0.825 4360000f 0.975 4400000f 0.975 4410000f 0.825 4450000f 0.825 4460000f 0.975 4500000f 0.975 4510000f 0.825 4550000f 0.825 4560000f 0.975 4600000f 0.975 4610000f 0.825 4650000f 0.825 4660000f 0.975 4700000f 0.975 4710000f 0.825 4750000f 0.825 4760000f 0.975 4800000f 0.975 4810000f 0.825 4850000f 0.825 4860000f 0.975 4900000f 0.975 4910000f 0.825 4950000f 0.825 4960000f 0.975 5000000f 0.975 5010000f 0.825 5050000f 0.825 5060000f 0.975 5100000f 0.975 5110000f 0.825 5150000f 0.825 5160000f 0.975 5200000f 0.975 5210000f 0.825 5250000f 0.825 5260000f 0.975 5300000f 0.975 5310000f 0.825 5350000f 0.825 5360000f 0.975 5400000f 0.975 5410000f 0.825 5450000f 0.825 5460000f 0.975 5500000f 0.975 5510000f 0.825 5550000f 0.825 5560000f 0.975 5600000f 0.975 5610000f 0.825 5650000f 0.825 5660000f 0.975 5700000f 0.975 5710000f 0.825 5750000f 0.825 5760000f 0.975 5800000f 0.975 5810000f 0.825 5850000f 0.825 5860000f 0.975 5900000f 0.975 5910000f 0.825 5950000f 0.825 5960000f 0.975 6000000f 0.975 6010000f 0.825 6050000f 0.825 6060000f 0.975 6100000f 0.975 6110000f 0.825 6150000f 0.825 6160000f 0.975 6200000f 0.975 6210000f 0.825 6250000f 0.825 6260000f 0.975 6300000f 0.975 6310000f 0.825 6350000f 0.825 6360000f 0.975 6400000f 0.975 6410000f 0.825 6450000f 0.825 6460000f 0.975 6500000f 0.975 6510000f 0.825 6550000f 0.825 6560000f 0.975 6600000f 0.975 6610000f 0.825 6650000f 0.825 6660000f 0.975 6700000f 0.975 6710000f 0.825 6750000f 0.825 6760000f 0.975 6800000f 0.975 6810000f 0.825 6850000f 0.825 6860000f 0.975 6900000f 0.975 6910000f 0.825 6950000f 0.825 6960000f 0.975 7000000f 0.975 7010000f 0.825 7050000f 0.825 7060000f 0.975 7100000f 0.975 7110000f 0.825 7150000f 0.825 7160000f 0.975 7200000f 0.975 7210000f 0.825 7250000f 0.825 7260000f 0.975 7300000f 0.975 7310000f 0.825 7350000f 0.825 7360000f 0.975 7400000f 0.975 7410000f 0.825 7450000f 0.825 7460000f 0.975 7500000f 0.975 7510000f 0.825 7550000f 0.825 7560000f 0.975 7600000f 0.975 7610000f 0.825 7650000f 0.825 7660000f 0.975 7700000f 0.975 7710000f 0.825 7750000f 0.825 7760000f 0.975 7800000f 0.975 7810000f 0.825 7850000f 0.825 7860000f 0.975 7900000f 0.975 7910000f 0.825 7950000f 0.825 7960000f 0.975 8000000f 0.975 8010000f 0.825 8050000f 0.825 8060000f 0.975 8100000f 0.975 8110000f 0.825 8150000f 0.825 8160000f 0.975 8200000f 0.975 8210000f 0.825 8250000f 0.825 8260000f 0.975 8300000f 0.975 8310000f 0.825 8350000f 0.825 8360000f 0.975 8400000f 0.975 8410000f 0.825 8450000f 0.825 8460000f 0.975 8500000f 0.975 8510000f 0.825 8550000f 0.825 8560000f 0.975 8600000f 0.975 8610000f 0.825 8650000f 0.825 8660000f 0.975 8700000f 0.975 8710000f 0.825 8750000f 0.825 8760000f 0.975 8800000f 0.975 8810000f 0.825 8850000f 0.825 8860000f 0.975 8900000f 0.975 8910000f 0.825 8950000f 0.825 8960000f 0.975 9000000f 0.975]
RCLKP (srcp clkp) resistor r=50
RCLKN (srcn clkn) resistor r=50
save srcp srcn
tran tran stop=9e-09 maxstep=1e-12 strobeperiod=1e-12 strobeoutput=strobeonly method=gear2only errpreset=conservative
