simulator lang=spectre
global 0
include "/home/IC/Tech/smic_018mmrf-OA/SMIC_018_MMRF/models/spectre/ms018_v1p7_spe.lib" section=tt
include "/home/IC/Tech/smic_018mmrf-OA/SMIC_018_MMRF/models/spectre/ms018_v1p7_spe.lib" section=mim_tt
include "/home/IC/Tech/smic_018mmrf-OA/SMIC_018_MMRF/models/spectre/ms018_v1p7_spe.lib" section=res_tt
include "/home/IC/CodeX/smic18_benchmark_repro/runs/18/20260928T181752376863Z_disabled/inputs/hd_cells.scs"
include "/home/IC/CodeX/smic18_benchmark_repro/runs/18/20260928T181752376863Z_disabled/inputs/circuit.scs"
VDD (src 0) vsource dc=1.8
VSENSE (src AVDD) vsource dc=0
IBIAS (src IBN1U) isource dc=1u
VEN (ensrc 0) vsource dc=0
REN (ensrc EN) resistor r=50
VCLK (clksrc 0) vsource dc=0
RCLK (clksrc CLK) resistor r=50
CLOAD (VOUT 0) capacitor c=1n
X (AVDD 0 CLK EN IBN1U VOUT) charge_pump_regulated
simulatorOptions options temp=40 tnom=27 reltol=1e-06 vabstol=1e-8 iabstol=1e-14
saveOptions options save=selected
save AVDD VOUT CLK EN IBN1U VSENSE:p VDD:p clksrc ensrc X.ENB X.gated X.ph0 X.ph1 X.bot0 X.bot1 X.p0 X.p1 X.vclk X.ctrl X.tail X.pd X.vnr X.vfb X.enr X.enf
dcOp dc
