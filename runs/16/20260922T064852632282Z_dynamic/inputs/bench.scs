simulator lang=spectre
global 0
include "/home/IC/Tech/smic_018mmrf-OA/SMIC_018_MMRF/models/spectre/ms018_v1p7_spe.lib" section=tt
include "/home/IC/CodeX/smic18_benchmark_repro/runs/16/20260922T064852632282Z_dynamic/inputs/circuit.scs"
simulatorOptions options temp=27 tnom=27 reltol=1e-6 vabstol=1e-9 iabstol=1e-15
saveOptions options save=selected
VDDS (vddS 0) vsource dc=1.8
IREFS (vddS irefS) isource dc=50u
VINS (vinS 0) vsource type=pwl wave=[0 .85 5n .85 6n .95 66n .95 67n .85 380n .85]
XS (0 irefS vddS outS vinS outS) two_stage_miller_opamp
CLS (outS 0) capacitor c=1p
save vinS outS VDDS:p
VDDR (vddR 0) vsource dc=1.8
IREFR (vddR irefR) isource dc=50u
VINR (vinR 0) vsource type=pwl wave=[0 .65 20n .65 21n 1.15 201n 1.15 202n .65 380n .65]
XR (0 irefR vddR outR vinR outR) two_stage_miller_opamp
CLR (outR 0) capacitor c=1p
save vinR outR VDDR:p
tran tran stop=380n maxstep=20p strobeperiod=100p strobeoutput=strobeonly errpreset=conservative
