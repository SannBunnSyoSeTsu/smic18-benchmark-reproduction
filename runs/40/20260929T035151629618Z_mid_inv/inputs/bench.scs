simulator lang=spectre
global 0
include "/home/IC/Tech/smic_018mmrf-OA/SMIC_018_MMRF/models/spectre/ms018_v1p7_spe.lib" section=tt
include "/home/IC/CodeX/smic18_benchmark_repro/runs/40/20260929T035151629618Z_mid_inv/inputs/circuit.scs"
VDD (vdd 0) vsource dc=1.8
VCM (vcm 0) vsource dc=.9
VVP (vp 0) vsource dc=1.3
VVN (vn 0) vsource dc=.5
VOCM (vocm 0) vsource dc=.9
IREF (vdd iref) isource dc=50u
VINP (vip vcm) vsource dc=-0.02 type=sine ampl=0.22 freq=39062.5 sinephase=225
VINN (vin vcm) vsource dc=0.02 type=sine ampl=0.22 freq=39062.5 sinephase=405
VOSP (sa_inp intp) vsource dc=.5m
VOSN (sa_inn intn) vsource dc=-.5m
X (0 vdd vip vin vp vn vcm ctrl_a ctrl_b c1a c1b c2a c2b intp intn inp inn iref vocm sa_inp sa_inn cmpclk) sigma_system
RBIP (inp vcm) resistor r=5Meg
RBIN (inn vcm) resistor r=5Meg
CLP (intp 0) capacitor c=1p
CLN (intn 0) capacitor c=1p
simulatorOptions options temp=27 tnom=27 reltol=1e-05 vabstol=1e-8 iabstol=1e-14 gmin=1e-15 cmin=1f
saveOptions options save=selected
save ctrl_a ctrl_b intp intn inp inn vip vin VDD:p X.XOTA.vcmfb X.XADC.hold_a X.XADC.hold_b X.XADC.dac_p X.XADC.dac_n X.XADC.cspt X.XADC.cspb c1a c2a
Vc1a (c1a_src 0) vsource type=pulse val0=0 val1=1.8 delay=0n rise=5n fall=5n width=34n period=100n
Rc1a (c1a_src c1a) resistor r=50
Vc1b (c1b_src 0) vsource type=pulse val0=1.8 val1=0 delay=0n rise=5n fall=5n width=34n period=100n
Rc1b (c1b_src c1b) resistor r=50
Vc2a (c2a_src 0) vsource type=pulse val0=0 val1=1.8 delay=50n rise=5n fall=5n width=34n period=100n
Rc2a (c2a_src c2a) resistor r=50
Vc2b (c2b_src 0) vsource type=pulse val0=1.8 val1=0 delay=50n rise=5n fall=5n width=34n period=100n
Rc2b (c2b_src c2b) resistor r=50
Vcmpclk (cmpclk_src 0) vsource type=pulse val0=0 val1=1.8 delay=100n rise=5n fall=5n width=34n period=100n
Rcmpclk (cmpclk_src cmpclk) resistor r=50
tran tran stop=58u maxstep=1e-09 skipdc=yes method=gear2only errpreset=conservative
