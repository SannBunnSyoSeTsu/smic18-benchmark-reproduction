simulator lang=spectre
global 0
include "/home/IC/Tech/smic_018mmrf-OA/SMIC_018_MMRF/models/spectre/ms018_v1p7_spe.lib" section=tt
include "/home/IC/CodeX/smic18_benchmark_repro/runs/50/20260922T100839104170Z_gpc_stb/inputs/gpc_probe.scs"
simulatorOptions options temp=27 tnom=27 reltol=1e-7 vabstol=1e-10 iabstol=1e-16
saveOptions options save=selected
VDD (vdd 0) vsource dc=1.8
IREF (vdd iref) isource dc=50u
X (0 iref vdd vinn vinp vout) folded_cascode_ota
CL (vout 0) capacitor c=1p
save vout vinn vinp VDD:p iref
VIN (vinp 0) vsource dc=.9
VTEST (vout vinn) vsource dc=0
save X.tail X.vbp X.vpc X.pcbs X.ncbs X.ncb X.nref X.pref X.p1 X.p2 X.mirror X.nfirst X.n1 X.n2 X.hs X.hr X.apt X.pgd X.gpc X.ant X.ngd X.gnc X.obias X.nout X.sinp X.sinn
save X.MREF:ids X.MREF:gm X.MREF:gds X.MREF:vgs X.MREF:vds X.MREF:vdsat X.MREF:region
save X.MTAIL:ids X.MTAIL:gm X.MTAIL:gds X.MTAIL:vgs X.MTAIL:vds X.MTAIL:vdsat X.MTAIL:region
save X.MNBP:ids X.MNBP:gm X.MNBP:gds X.MNBP:vgs X.MNBP:vds X.MNBP:vdsat X.MNBP:region
save X.MPBP:ids X.MPBP:gm X.MPBP:gds X.MPBP:vgs X.MPBP:vds X.MPBP:vdsat X.MPBP:region
save X.MNPC:ids X.MNPC:gm X.MNPC:gds X.MNPC:vgs X.MNPC:vds X.MNPC:vdsat X.MNPC:region
save X.MPPC:ids X.MPPC:gm X.MPPC:gds X.MPPC:vgs X.MPPC:vds X.MPPC:vdsat X.MPPC:region
save X.MPB2:ids X.MPB2:gm X.MPB2:gds X.MPB2:vgs X.MPB2:vds X.MPB2:vdsat X.MPB2:region
save X.MNCB:ids X.MNCB:gm X.MNCB:gds X.MNCB:vgs X.MNCB:vds X.MNCB:vdsat X.MNCB:region
save X.MNRBI:ids X.MNRBI:gm X.MNRBI:gds X.MNRBI:vgs X.MNRBI:vds X.MNRBI:vdsat X.MNRBI:region
save X.MNRS:ids X.MNRS:gm X.MNRS:gds X.MNRS:vgs X.MNRS:vds X.MNRS:vdsat X.MNRS:region
save X.MPRBI:ids X.MPRBI:gm X.MPRBI:gds X.MPRBI:vgs X.MPRBI:vds X.MPRBI:vdsat X.MPRBI:region
save X.MPRS:ids X.MPRS:gm X.MPRS:gds X.MPRS:vgs X.MPRS:vds X.MPRS:vdsat X.MPRS:region
save X.MINP:ids X.MINP:gm X.MINP:gds X.MINP:vgs X.MINP:vds X.MINP:vdsat X.MINP:region
save X.MINN:ids X.MINN:gm X.MINN:gds X.MINN:vgs X.MINN:vds X.MINN:vdsat X.MINN:region
save X.MFP:ids X.MFP:gm X.MFP:gds X.MFP:vgs X.MFP:vds X.MFP:vdsat X.MFP:region
save X.MFN:ids X.MFN:gm X.MFN:gds X.MFN:vgs X.MFN:vds X.MFN:vdsat X.MFN:region
save X.MFCP:ids X.MFCP:gm X.MFCP:gds X.MFCP:vgs X.MFCP:vds X.MFCP:vdsat X.MFCP:region
save X.MFCN:ids X.MFCN:gm X.MFCN:gds X.MFCN:vgs X.MFCN:vds X.MFCN:vdsat X.MFCN:region
save X.MMD:ids X.MMD:gm X.MMD:gds X.MMD:vgs X.MMD:vds X.MMD:vdsat X.MMD:region
save X.MMO:ids X.MMO:gm X.MMO:gds X.MMO:vgs X.MMO:vds X.MMO:vdsat X.MMO:region
save X.MCD:ids X.MCD:gm X.MCD:gds X.MCD:vgs X.MCD:vds X.MCD:vdsat X.MCD:region
save X.MCO:ids X.MCO:gm X.MCO:gds X.MCO:vgs X.MCO:vds X.MCO:vdsat X.MCO:region
save X.MHSI:ids X.MHSI:gm X.MHSI:gds X.MHSI:vgs X.MHSI:vds X.MHSI:vdsat X.MHSI:region
save X.MHSF:ids X.MHSF:gm X.MHSF:gds X.MHSF:vgs X.MHSF:vds X.MHSF:vdsat X.MHSF:region
save X.MHRI:ids X.MHRI:gm X.MHRI:gds X.MHRI:vgs X.MHRI:vds X.MHRI:vdsat X.MHRI:region
save X.MHRF:ids X.MHRF:gm X.MHRF:gds X.MHRF:vgs X.MHRF:vds X.MHRF:vdsat X.MHRF:region
save X.MPT:ids X.MPT:gm X.MPT:gds X.MPT:vgs X.MPT:vds X.MPT:vdsat X.MPT:region
save X.MPA:ids X.MPA:gm X.MPA:gds X.MPA:vgs X.MPA:vds X.MPA:vdsat X.MPA:region
save X.MPB:ids X.MPB:gm X.MPB:gds X.MPB:vgs X.MPB:vds X.MPB:vdsat X.MPB:region
save X.MPMA:ids X.MPMA:gm X.MPMA:gds X.MPMA:vgs X.MPMA:vds X.MPMA:vdsat X.MPMA:region
save X.MPMB:ids X.MPMB:gm X.MPMB:gds X.MPMB:vgs X.MPMB:vds X.MPMB:vdsat X.MPMB:region
save X.MNT:ids X.MNT:gm X.MNT:gds X.MNT:vgs X.MNT:vds X.MNT:vdsat X.MNT:region
save X.MNA:ids X.MNA:gm X.MNA:gds X.MNA:vgs X.MNA:vds X.MNA:vdsat X.MNA:region
save X.MNB:ids X.MNB:gm X.MNB:gds X.MNB:vgs X.MNB:vds X.MNB:vdsat X.MNB:region
save X.MNMA:ids X.MNMA:gm X.MNMA:gds X.MNMA:vgs X.MNMA:vds X.MNMA:vdsat X.MNMA:region
save X.MNMB:ids X.MNMB:gm X.MNMB:gds X.MNMB:vgs X.MNMB:vds X.MNMB:vdsat X.MNMB:region
save X.MOBN:ids X.MOBN:gm X.MOBN:gds X.MOBN:vgs X.MOBN:vds X.MOBN:vdsat X.MOBN:region
save X.MOBP:ids X.MOBP:gm X.MOBP:gds X.MOBP:vgs X.MOBP:vds X.MOBP:vdsat X.MOBP:region
save X.MOUT:ids X.MOUT:gm X.MOUT:gds X.MOUT:vgs X.MOUT:vds X.MOUT:vdsat X.MOUT:region
save X.MOUTC:ids X.MOUTC:gm X.MOUTC:gds X.MOUTC:vgs X.MOUTC:vds X.MOUTC:vdsat X.MOUTC:region
save X.MLOAD:ids X.MLOAD:gm X.MLOAD:gds X.MLOAD:vgs X.MLOAD:vds X.MLOAD:vdsat X.MLOAD:region
dcOp dc
localstb stb start=1 stop=100G dec=100 probe=X.PL
