simulator lang=spectre
global 0
include "/home/IC/Tech/smic_018mmrf-OA/SMIC_018_MMRF/models/spectre/ms018_v1p7_spe.lib" section=tt
include "/home/IC/CodeX/smic18_benchmark_repro/runs/50/20260922T100811101938Z_range/inputs/circuit.scs"
simulatorOptions options temp=27 tnom=27 reltol=1e-7 vabstol=1e-10 iabstol=1e-16
saveOptions options save=selected
VDD (vdd 0) vsource dc=1.8
IREF (vdd iref) isource dc=50u
X (0 iref vdd vinn vinp vout) folded_cascode_ota
CL (vout 0) capacitor c=1p
save vout vinn vinp VDD:p iref
parameters command=.9
VIN (vinp 0) vsource dc=command
VFB (vout vinn) vsource dc=0
swing dc param=command start=.3 stop=1.5 step=.01
