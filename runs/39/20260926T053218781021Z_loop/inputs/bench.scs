simulator lang=spectre
global 0
include "/home/IC/Tech/smic_018mmrf-OA/SMIC_018_MMRF/models/spectre/ms018_v1p7_spe.lib" section=tt
include "/home/IC/CodeX/smic18_benchmark_repro/runs/39/20260926T053218781021Z_loop/inputs/circuit.scs"
simulatorOptions options temp=27 tnom=27 reltol=1e-06 vabstol=1e-10 iabstol=1e-15
saveOptions options save=selected
VDD (vdd 0) vsource dc=1.8
IREF (vdd iref) isource dc=50u
VINP (vinp 0) vsource dc=.9
R1 (vs vinn) resistor r=10k
X (0 iref vdd vinn vinp vout) low_power_line_driver
CAC (vout la) capacitor c=1u
RL (la 0) resistor r=300
CL (vout 0) capacitor c=200p
save vs vinn vinp vout la vdd VDD:p X.gp X.gn X.tail X.pb X.vbn X.vbp X.xn X.yp
VS (vs 0) vsource dc=.9
R2 (vinn fbv) resistor r=10k
VTEST (fbv vout) vsource dc=0 mag=1
save fbv
save X.MREF:ids X.MREF:gm X.MREF:gds X.MREF:vgs X.MREF:vds X.MREF:vdsat X.MREF:region
save X.MTAIL:ids X.MTAIL:gm X.MTAIL:gds X.MTAIL:vgs X.MTAIL:vds X.MTAIL:vdsat X.MTAIL:region
save X.MBN:ids X.MBN:gm X.MBN:gds X.MBN:vgs X.MBN:vds X.MBN:vdsat X.MBN:region
save X.MBP:ids X.MBP:gm X.MBP:gds X.MBP:vgs X.MBP:vds X.MBP:vdsat X.MBP:region
save X.MABNS:ids X.MABNS:gm X.MABNS:gds X.MABNS:vgs X.MABNS:vds X.MABNS:vdsat X.MABNS:region
save X.MABNU:ids X.MABNU:gm X.MABNU:gds X.MABNU:vgs X.MABNU:vds X.MABNU:vdsat X.MABNU:region
save X.MABNL:ids X.MABNL:gm X.MABNL:gds X.MABNL:vgs X.MABNL:vds X.MABNL:vdsat X.MABNL:region
save X.MABPS:ids X.MABPS:gm X.MABPS:gds X.MABPS:vgs X.MABPS:vds X.MABPS:vdsat X.MABPS:region
save X.MABPU:ids X.MABPU:gm X.MABPU:gds X.MABPU:vgs X.MABPU:vds X.MABPU:vdsat X.MABPU:region
save X.MABPL:ids X.MABPL:gm X.MABPL:gds X.MABPL:vgs X.MABPL:vds X.MABPL:vdsat X.MABPL:region
save X.MINP:ids X.MINP:gm X.MINP:gds X.MINP:vgs X.MINP:vds X.MINP:vdsat X.MINP:region
save X.MINN:ids X.MINN:gm X.MINN:gds X.MINN:vgs X.MINN:vds X.MINN:vdsat X.MINN:region
save X.MP3:ids X.MP3:gm X.MP3:gds X.MP3:vgs X.MP3:vds X.MP3:vdsat X.MP3:region
save X.MP4:ids X.MP4:gm X.MP4:gds X.MP4:vgs X.MP4:vds X.MP4:vdsat X.MP4:region
save X.MP5:ids X.MP5:gm X.MP5:gds X.MP5:vgs X.MP5:vds X.MP5:vdsat X.MP5:region
save X.MP6:ids X.MP6:gm X.MP6:gds X.MP6:vgs X.MP6:vds X.MP6:vdsat X.MP6:region
save X.MN7:ids X.MN7:gm X.MN7:gds X.MN7:vgs X.MN7:vds X.MN7:vdsat X.MN7:region
save X.MN8:ids X.MN8:gm X.MN8:gds X.MN8:vgs X.MN8:vds X.MN8:vdsat X.MN8:region
save X.MCN:ids X.MCN:gm X.MCN:gds X.MCN:vgs X.MCN:vds X.MCN:vdsat X.MCN:region
save X.MCP:ids X.MCP:gm X.MCP:gds X.MCP:vgs X.MCP:vds X.MCP:vdsat X.MCP:region
save X.MOUTP:ids X.MOUTP:gm X.MOUTP:gds X.MOUTP:vgs X.MOUTP:vds X.MOUTP:vdsat X.MOUTP:region
save X.MOUTN:ids X.MOUTN:gm X.MOUTN:gds X.MOUTN:vgs X.MOUTN:vds X.MOUTN:vdsat X.MOUTN:region
dcOp dc
ac ac start=1 stop=1G dec=60
