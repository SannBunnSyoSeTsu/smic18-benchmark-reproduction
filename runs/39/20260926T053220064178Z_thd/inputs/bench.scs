simulator lang=spectre
global 0
include "/home/IC/Tech/smic_018mmrf-OA/SMIC_018_MMRF/models/spectre/ms018_v1p7_spe.lib" section=tt
include "/home/IC/CodeX/smic18_benchmark_repro/runs/39/20260926T053220064178Z_thd/inputs/circuit.scs"
simulatorOptions options temp=27 tnom=27 reltol=1e-06 vabstol=1e-10 iabstol=1e-15
saveOptions options save=selected
VDD (vdd 0) vsource dc=1.8
IREF (vdd iref) isource dc=50u
VINP (vinp 0) vsource dc=.9
R1 (vs vinn) resistor r=10k
X (0 iref vdd vinn vinp vout) low_power_line_driver
CAC (vout la) capacitor c=1u
RL (la 0) resistor r=300
CL (vout 0) capacitor c=200p
save vs vinn vinp vout la vdd VDD:p X.gp X.gn X.tail X.pb X.vbn X.vbp X.xn X.yp
R2 (vinn vout) resistor r=10k
VS (vs 0) vsource dc=.9 type=sine ampl=.6 freq=20k
save X.MOUTN:ids X.MOUTP:ids
tran tran stop=400u maxstep=100n method=gear2only errpreset=conservative
