simulator lang=spectre
global 0
include "/home/IC/Tech/smic_018mmrf-OA/SMIC_018_MMRF/models/spectre/ms018_v1p7_spe.lib" section=tt
include "/home/IC/CodeX/smic18_benchmark_repro/runs/22/20260922T094323883356Z_static/inputs/circuit.scs"
simulatorOptions options temp=27 tnom=27 reltol=2e-6 vabstol=1e-9 iabstol=1e-12
saveOptions options save=selected
include "/home/IC/CodeX/smic18_benchmark_repro/runs/22/20260922T094323883356Z_static/inputs/hd_cells.scs"
VDD (vdd 0) vsource dc=1.8
VCLKDD (clk_vdd 0) vsource dc=1.8
VCLKIN (clk_src 0) vsource type=pwl wave=[0 0 1e-09 0 1.05e-09 1.8 5.05e-09 1.8 5.1e-09 0 1.1e-08 0 1.105e-08 1.8 1.505e-08 1.8 1.51e-08 0 2.1e-08 0 2.105e-08 1.8 2.505e-08 1.8 2.51e-08 0 3e-08 0]
RCLK (clk_src clk_in) resistor r=50
XCLK1 (clk_in clk_b clk_vdd 0 clk_vdd 0) INHDV8
XCLK2 (clk_b clk clk_vdd 0 clk_vdd 0) INHDV16
save clk_src clk_in clk_b clk VDD:p VCLKDD:p VCLKIN:p
VINPP (vinpP 0) vsource type=pwl wave=[0 1.3 22n 1.3 22.1n 0.5 30n 0.5]
MSWPP (voutpP gatepP vinpP 0) n18 w=64u l=.18u
COUTPP (voutpP 0) capacitor c=1p
VINNP (vinnP 0) vsource type=pwl wave=[0 0.5 22n 0.5 22.1n 1.3 30n 1.3]
MSWNP (voutnP gatenP vinnP 0) n18 w=64u l=.18u
COUTNP (voutnP 0) capacitor c=1p
XP (vdd 0 clk vinpP vinnP gatepP gatenP) bootstrap_gate_driver
save vinpP vinnP gatepP gatenP voutpP voutnP VINPP:p VINNP:p
save XP.XBP.CLKP XP.XBP.CG XP.XBP.CBB XP.XBP.CBT XP.XBP.PRE XP.XBN.CLKP XP.XBN.CG XP.XBN.CBB XP.XBN.CBT XP.XBN.PRE
VINPN (vinpN 0) vsource type=pwl wave=[0 0.5 22n 0.5 22.1n 1.3 30n 1.3]
MSWPN (voutpN gatepN vinpN 0) n18 w=64u l=.18u
COUTPN (voutpN 0) capacitor c=1p
VINNN (vinnN 0) vsource type=pwl wave=[0 1.3 22n 1.3 22.1n 0.5 30n 0.5]
MSWNN (voutnN gatenN vinnN 0) n18 w=64u l=.18u
COUTNN (voutnN 0) capacitor c=1p
XN (vdd 0 clk vinpN vinnN gatepN gatenN) bootstrap_gate_driver
save vinpN vinnN gatepN gatenN voutpN voutnN VINPN:p VINNN:p
save XN.XBP.CLKP XN.XBP.CG XN.XBP.CBB XN.XBP.CBT XN.XBP.PRE XN.XBN.CLKP XN.XBN.CG XN.XBN.CBB XN.XBN.CBT XN.XBN.PRE
tran tran stop=3e-08 maxstep=2.5p errpreset=conservative
