simulator lang=spectre
global 0
parameters vtest=.9
include "/home/IC/Tech/smic_018mmrf-OA/SMIC_018_MMRF/models/spectre/ms018_v1p7_spe.lib" section=tt
include "/home/IC/Tech/smic_018mmrf-OA/SMIC_018_MMRF/models/spectre/ms018_v1p7_spe.lib" section=res_tt
include "/home/IC/CodeX/smic18_benchmark_repro/runs/12/20260922T063724757608Z_startup_1us/inputs/circuit.scs"
VDD (vdd 0) vsource type=pwl wave=[0 0 1e-06 1.8 1.1000000000000001e-05 1.8]
VOUT (iout 0) vsource dc=vtest
XDUT (0 vdd vref iout) beta_multiplier_reference
simulatorOptions options temp=27 tnom=27 reltol=1e-6 vabstol=1e-9 iabstol=1e-15
saveOptions options save=selected
save vdd vref iout XDUT.na XDUT.nr XDUT.nx VDD:p VOUT:p
save XDUT.MP1:ids XDUT.MP1:gm XDUT.MP1:gds XDUT.MP1:vgs XDUT.MP1:vds XDUT.MP1:vdsat XDUT.MP1:region
save XDUT.MP2:ids XDUT.MP2:gm XDUT.MP2:gds XDUT.MP2:vgs XDUT.MP2:vds XDUT.MP2:vdsat XDUT.MP2:region
save XDUT.MN1:ids XDUT.MN1:gm XDUT.MN1:gds XDUT.MN1:vgs XDUT.MN1:vds XDUT.MN1:vdsat XDUT.MN1:region
save XDUT.MN2:ids XDUT.MN2:gm XDUT.MN2:gds XDUT.MN2:vgs XDUT.MN2:vds XDUT.MN2:vdsat XDUT.MN2:region
save XDUT.MOUT:ids XDUT.MOUT:gm XDUT.MOUT:gds XDUT.MOUT:vgs XDUT.MOUT:vds XDUT.MOUT:vdsat XDUT.MOUT:region
save XDUT.MPUP:ids XDUT.MPUP:gm XDUT.MPUP:gds XDUT.MPUP:vgs XDUT.MPUP:vds XDUT.MPUP:vdsat XDUT.MPUP:region
save XDUT.MDET:ids XDUT.MDET:gm XDUT.MDET:gds XDUT.MDET:vgs XDUT.MDET:vds XDUT.MDET:vdsat XDUT.MDET:region
save XDUT.MSTART:ids XDUT.MSTART:gm XDUT.MSTART:gds XDUT.MSTART:vgs XDUT.MSTART:vds XDUT.MSTART:vdsat XDUT.MSTART:region
tran tran stop=1.1e-05 maxstep=2n strobeperiod=5n strobeoutput=strobeonly errpreset=conservative
