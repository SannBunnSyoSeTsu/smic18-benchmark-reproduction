simulator lang=spectre
global 0
include "/home/IC/Tech/smic_018mmrf-OA/SMIC_018_MMRF/models/spectre/ms018_v1p7_spe.lib" section=tt
include "/home/IC/CodeX/smic18_benchmark_repro/runs/46/20260928T180537281650Z_transition/inputs/hd_cells.scs"
include "/home/IC/CodeX/smic18_benchmark_repro/runs/46/20260928T180537281650Z_transition/inputs/circuit.scs"
VDD (vdd 0) vsource dc=1.8
VREFP (vrefp 0) vsource dc=1.4
VREFN (vrefn 0) vsource dc=.6
VCLK (clk_src 0) vsource type=pulse val0=0 val1=1.8 delay=10n rise=.3n fall=.3n width=9.4n period=20n
RCLK (clk_src clk) resistor r=50
CB2 (b2 0) capacitor c=15f
CB1 (b1 0) capacitor c=15f
CB0 (b0 0) capacitor c=15f
X (0 vdd vrefn vrefp clk vin b2 b1 b0) flash_adc_3bit
simulatorOptions options temp=27 tnom=27 reltol=1e-06 vabstol=1e-8 iabstol=1e-14 gmin=1e-15
saveOptions options save=selected
save vin vdd clk_src clk b2 b1 b0 VDD:p VREFP:p VREFN:p VCLK:p X.t1 X.t2 X.t3 X.t4 X.t5 X.t6 X.t7
VIN (vin 0) vsource type=pwl wave=[0 0.65 2e-08 0.65 2.04e-08 1.35 4e-08 1.35 4.04e-08 0.95 6e-08 0.95 6.04e-08 1.15 8e-08 1.15 8.04e-08 0.75 1e-07 0.75 1.004e-07 1.25 1.2e-07 1.25 1.204e-07 0.85 1.4e-07 0.85 1.404e-07 1.05 1.6e-07 1.05 1.604e-07 1.35 1.8e-07 1.35 1.804e-07 0.65 2e-07 0.65 2.004e-07 1.05 2.2e-07 1.05 2.204e-07 0.85 2.4e-07 0.85 2.404e-07 1.25 2.6e-07 1.25 2.604e-07 0.75 2.8e-07 0.75 2.804e-07 1.15 3e-07 1.15 3.004e-07 0.95 3.2e-07 0.95 3.204e-07 1.35 3.4e-07 1.35 3.404e-07 0.65 3.6e-07 0.65 3.604e-07 0.85 3.8e-07 0.85 3.804e-07 1.15 4e-07 1.15 4.004e-07 0.65 4.2e-07 0.65 4.204e-07 1.35 4.4e-07 1.35 4.404e-07 0.75 4.6e-07 0.75 4.604e-07 1.25 4.8e-07 1.25 4.804e-07 0.95 5e-07 0.95 5.004e-07 1.05 5.4e-07 1.05]
tran tran stop=5.4e-07 maxstep=1e-10 method=gear2only errpreset=conservative
