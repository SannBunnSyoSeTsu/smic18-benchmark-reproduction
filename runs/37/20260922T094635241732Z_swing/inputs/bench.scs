simulator lang=spectre
global 0
include "/home/IC/Tech/smic_018mmrf-OA/SMIC_018_MMRF/models/spectre/ms018_v1p7_spe.lib" section=tt
include "/home/IC/CodeX/smic18_benchmark_repro/runs/37/20260922T094635241732Z_swing/inputs/circuit.scs"
simulatorOptions options temp=27 tnom=27 reltol=1e-6 vabstol=1e-9 iabstol=1e-15
saveOptions options save=selected
VDD (vdd 0) vsource dc=1.8
IREF (vdd iref) isource dc=5u
X (0 iref vdd vinn vinp vout) three_stage_nmc_ota
CL (vout 0) capacitor c=200p
save vout vinn vinp VDD:p iref
parameters command=.9
VIN (vinp 0) vsource dc=command
VFB (vout vinn) vsource dc=0
swing dc param=command start=.1 stop=1.7 step=.002
