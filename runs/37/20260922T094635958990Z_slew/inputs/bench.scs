simulator lang=spectre
global 0
include "/home/IC/Tech/smic_018mmrf-OA/SMIC_018_MMRF/models/spectre/ms018_v1p7_spe.lib" section=tt
include "/home/IC/CodeX/smic18_benchmark_repro/runs/37/20260922T094635958990Z_slew/inputs/circuit.scs"
simulatorOptions options temp=27 tnom=27 reltol=1e-6 vabstol=1e-9 iabstol=1e-15
saveOptions options save=selected
VDD (vdd 0) vsource dc=1.8
IREF (vdd iref) isource dc=5u
X (0 iref vdd vinn vinp vout) three_stage_nmc_ota
CL (vout 0) capacitor c=200p
save vout vinn vinp VDD:p iref
VIN (vinp 0) vsource type=pwl wave=[0 .65 2u .65 2.1u 1.15 42.1u 1.15 42.2u .65 82u .65]
VFB (vout vinn) vsource dc=0
tran tran stop=82u maxstep=5e-09 strobeperiod=1e-08 strobeoutput=strobeonly errpreset=conservative method=gear2only
