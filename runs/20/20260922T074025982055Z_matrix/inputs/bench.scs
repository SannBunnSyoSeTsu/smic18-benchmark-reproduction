simulator lang=spectre
global 0
include "/home/IC/Tech/smic_018mmrf-OA/SMIC_018_MMRF/models/spectre/ms018_v1p7_spe.lib" section=tt
include "/home/IC/CodeX/smic18_benchmark_repro/runs/20/20260922T074025982055Z_matrix/inputs/circuit.scs"
simulatorOptions options temp=40 tnom=27 reltol=1e-6 vabstol=1e-9 iabstol=1e-15
saveOptions options save=selected
include "/home/IC/CodeX/smic18_benchmark_repro/runs/20/20260922T074025982055Z_matrix/inputs/hd_cells.scs"
VDD0_0_0 (vdsrc0_0_0 0) vsource dc=1.8
RVD0_0_0 (vdsrc0_0_0 vdd0_0_0) resistor r=50
VS0_0_0_0 (ss0_0_0_0 0) vsource dc=0
RS0_0_0_0 (ss0_0_0_0 s0_0_0_0) resistor r=50
VS1_0_0_0 (ss1_0_0_0 0) vsource dc=0
RS1_0_0_0 (ss1_0_0_0 s1_0_0_0) resistor r=50
VS2_0_0_0 (ss2_0_0_0 0) vsource dc=0
RS2_0_0_0 (ss2_0_0_0 s2_0_0_0) resistor r=50
VI0_0_0_0 (vs0_0_0_0 0) vsource dc=0 mag=1
RI0_0_0_0 (vs0_0_0_0 vi0_0_0_0) resistor r=50
VI1_0_0_0 (vs1_0_0_0 0) vsource dc=0 mag=0
RI1_0_0_0 (vs1_0_0_0 vi1_0_0_0) resistor r=50
VI2_0_0_0 (vs2_0_0_0 0) vsource dc=0 mag=0
RI2_0_0_0 (vs2_0_0_0 vi2_0_0_0) resistor r=50
VI3_0_0_0 (vs3_0_0_0 0) vsource dc=0 mag=0
RI3_0_0_0 (vs3_0_0_0 vi3_0_0_0) resistor r=50
VI4_0_0_0 (vs4_0_0_0 0) vsource dc=0 mag=0
RI4_0_0_0 (vs4_0_0_0 vi4_0_0_0) resistor r=50
VI5_0_0_0 (vs5_0_0_0 0) vsource dc=0 mag=0
RI5_0_0_0 (vs5_0_0_0 vi5_0_0_0) resistor r=50
VI6_0_0_0 (vs6_0_0_0 0) vsource dc=0 mag=0
RI6_0_0_0 (vs6_0_0_0 vi6_0_0_0) resistor r=50
VI7_0_0_0 (vs7_0_0_0 0) vsource dc=0 mag=0
RI7_0_0_0 (vs7_0_0_0 vi7_0_0_0) resistor r=50
X0_0_0 (vdd0_0_0 0 s2_0_0_0 s1_0_0_0 s0_0_0_0 vi7_0_0_0 vi6_0_0_0 vi5_0_0_0 vi4_0_0_0 vi3_0_0_0 vi2_0_0_0 vi1_0_0_0 vi0_0_0_0 vo0_0_0) input_mux_8to1
CL0_0_0 (vo0_0_0 0) capacitor c=1p
save vo0_0_0 VDD0_0_0:p
save X0_0_0.XSW0.MN:gds
save X0_0_0.XSW0.MP:gds
save X0_0_0.XSW8.MN:gds
save X0_0_0.XSW8.MP:gds
save X0_0_0.XSW12.MN:gds
save X0_0_0.XSW12.MP:gds
VDD0_0_1 (vdsrc0_0_1 0) vsource dc=1.8
RVD0_0_1 (vdsrc0_0_1 vdd0_0_1) resistor r=50
VS0_0_0_1 (ss0_0_0_1 0) vsource dc=0
RS0_0_0_1 (ss0_0_0_1 s0_0_0_1) resistor r=50
VS1_0_0_1 (ss1_0_0_1 0) vsource dc=0
RS1_0_0_1 (ss1_0_0_1 s1_0_0_1) resistor r=50
VS2_0_0_1 (ss2_0_0_1 0) vsource dc=0
RS2_0_0_1 (ss2_0_0_1 s2_0_0_1) resistor r=50
VI0_0_0_1 (vs0_0_0_1 0) vsource dc=0 mag=0
RI0_0_0_1 (vs0_0_0_1 vi0_0_0_1) resistor r=50
VI1_0_0_1 (vs1_0_0_1 0) vsource dc=0 mag=1
RI1_0_0_1 (vs1_0_0_1 vi1_0_0_1) resistor r=50
VI2_0_0_1 (vs2_0_0_1 0) vsource dc=0 mag=0
RI2_0_0_1 (vs2_0_0_1 vi2_0_0_1) resistor r=50
VI3_0_0_1 (vs3_0_0_1 0) vsource dc=0 mag=0
RI3_0_0_1 (vs3_0_0_1 vi3_0_0_1) resistor r=50
VI4_0_0_1 (vs4_0_0_1 0) vsource dc=0 mag=0
RI4_0_0_1 (vs4_0_0_1 vi4_0_0_1) resistor r=50
VI5_0_0_1 (vs5_0_0_1 0) vsource dc=0 mag=0
RI5_0_0_1 (vs5_0_0_1 vi5_0_0_1) resistor r=50
VI6_0_0_1 (vs6_0_0_1 0) vsource dc=0 mag=0
RI6_0_0_1 (vs6_0_0_1 vi6_0_0_1) resistor r=50
VI7_0_0_1 (vs7_0_0_1 0) vsource dc=0 mag=0
RI7_0_0_1 (vs7_0_0_1 vi7_0_0_1) resistor r=50
X0_0_1 (vdd0_0_1 0 s2_0_0_1 s1_0_0_1 s0_0_0_1 vi7_0_0_1 vi6_0_0_1 vi5_0_0_1 vi4_0_0_1 vi3_0_0_1 vi2_0_0_1 vi1_0_0_1 vi0_0_0_1 vo0_0_1) input_mux_8to1
CL0_0_1 (vo0_0_1 0) capacitor c=1p
save vo0_0_1 VDD0_0_1:p
VDD0_0_2 (vdsrc0_0_2 0) vsource dc=1.8
RVD0_0_2 (vdsrc0_0_2 vdd0_0_2) resistor r=50
VS0_0_0_2 (ss0_0_0_2 0) vsource dc=0
RS0_0_0_2 (ss0_0_0_2 s0_0_0_2) resistor r=50
VS1_0_0_2 (ss1_0_0_2 0) vsource dc=0
RS1_0_0_2 (ss1_0_0_2 s1_0_0_2) resistor r=50
VS2_0_0_2 (ss2_0_0_2 0) vsource dc=0
RS2_0_0_2 (ss2_0_0_2 s2_0_0_2) resistor r=50
VI0_0_0_2 (vs0_0_0_2 0) vsource dc=0 mag=0
RI0_0_0_2 (vs0_0_0_2 vi0_0_0_2) resistor r=50
VI1_0_0_2 (vs1_0_0_2 0) vsource dc=0 mag=0
RI1_0_0_2 (vs1_0_0_2 vi1_0_0_2) resistor r=50
VI2_0_0_2 (vs2_0_0_2 0) vsource dc=0 mag=1
RI2_0_0_2 (vs2_0_0_2 vi2_0_0_2) resistor r=50
VI3_0_0_2 (vs3_0_0_2 0) vsource dc=0 mag=0
RI3_0_0_2 (vs3_0_0_2 vi3_0_0_2) resistor r=50
VI4_0_0_2 (vs4_0_0_2 0) vsource dc=0 mag=0
RI4_0_0_2 (vs4_0_0_2 vi4_0_0_2) resistor r=50
VI5_0_0_2 (vs5_0_0_2 0) vsource dc=0 mag=0
RI5_0_0_2 (vs5_0_0_2 vi5_0_0_2) resistor r=50
VI6_0_0_2 (vs6_0_0_2 0) vsource dc=0 mag=0
RI6_0_0_2 (vs6_0_0_2 vi6_0_0_2) resistor r=50
VI7_0_0_2 (vs7_0_0_2 0) vsource dc=0 mag=0
RI7_0_0_2 (vs7_0_0_2 vi7_0_0_2) resistor r=50
X0_0_2 (vdd0_0_2 0 s2_0_0_2 s1_0_0_2 s0_0_0_2 vi7_0_0_2 vi6_0_0_2 vi5_0_0_2 vi4_0_0_2 vi3_0_0_2 vi2_0_0_2 vi1_0_0_2 vi0_0_0_2 vo0_0_2) input_mux_8to1
CL0_0_2 (vo0_0_2 0) capacitor c=1p
save vo0_0_2 VDD0_0_2:p
VDD0_0_3 (vdsrc0_0_3 0) vsource dc=1.8
RVD0_0_3 (vdsrc0_0_3 vdd0_0_3) resistor r=50
VS0_0_0_3 (ss0_0_0_3 0) vsource dc=0
RS0_0_0_3 (ss0_0_0_3 s0_0_0_3) resistor r=50
VS1_0_0_3 (ss1_0_0_3 0) vsource dc=0
RS1_0_0_3 (ss1_0_0_3 s1_0_0_3) resistor r=50
VS2_0_0_3 (ss2_0_0_3 0) vsource dc=0
RS2_0_0_3 (ss2_0_0_3 s2_0_0_3) resistor r=50
VI0_0_0_3 (vs0_0_0_3 0) vsource dc=0 mag=0
RI0_0_0_3 (vs0_0_0_3 vi0_0_0_3) resistor r=50
VI1_0_0_3 (vs1_0_0_3 0) vsource dc=0 mag=0
RI1_0_0_3 (vs1_0_0_3 vi1_0_0_3) resistor r=50
VI2_0_0_3 (vs2_0_0_3 0) vsource dc=0 mag=0
RI2_0_0_3 (vs2_0_0_3 vi2_0_0_3) resistor r=50
VI3_0_0_3 (vs3_0_0_3 0) vsource dc=0 mag=1
RI3_0_0_3 (vs3_0_0_3 vi3_0_0_3) resistor r=50
VI4_0_0_3 (vs4_0_0_3 0) vsource dc=0 mag=0
RI4_0_0_3 (vs4_0_0_3 vi4_0_0_3) resistor r=50
VI5_0_0_3 (vs5_0_0_3 0) vsource dc=0 mag=0
RI5_0_0_3 (vs5_0_0_3 vi5_0_0_3) resistor r=50
VI6_0_0_3 (vs6_0_0_3 0) vsource dc=0 mag=0
RI6_0_0_3 (vs6_0_0_3 vi6_0_0_3) resistor r=50
VI7_0_0_3 (vs7_0_0_3 0) vsource dc=0 mag=0
RI7_0_0_3 (vs7_0_0_3 vi7_0_0_3) resistor r=50
X0_0_3 (vdd0_0_3 0 s2_0_0_3 s1_0_0_3 s0_0_0_3 vi7_0_0_3 vi6_0_0_3 vi5_0_0_3 vi4_0_0_3 vi3_0_0_3 vi2_0_0_3 vi1_0_0_3 vi0_0_0_3 vo0_0_3) input_mux_8to1
CL0_0_3 (vo0_0_3 0) capacitor c=1p
save vo0_0_3 VDD0_0_3:p
VDD0_0_4 (vdsrc0_0_4 0) vsource dc=1.8
RVD0_0_4 (vdsrc0_0_4 vdd0_0_4) resistor r=50
VS0_0_0_4 (ss0_0_0_4 0) vsource dc=0
RS0_0_0_4 (ss0_0_0_4 s0_0_0_4) resistor r=50
VS1_0_0_4 (ss1_0_0_4 0) vsource dc=0
RS1_0_0_4 (ss1_0_0_4 s1_0_0_4) resistor r=50
VS2_0_0_4 (ss2_0_0_4 0) vsource dc=0
RS2_0_0_4 (ss2_0_0_4 s2_0_0_4) resistor r=50
VI0_0_0_4 (vs0_0_0_4 0) vsource dc=0 mag=0
RI0_0_0_4 (vs0_0_0_4 vi0_0_0_4) resistor r=50
VI1_0_0_4 (vs1_0_0_4 0) vsource dc=0 mag=0
RI1_0_0_4 (vs1_0_0_4 vi1_0_0_4) resistor r=50
VI2_0_0_4 (vs2_0_0_4 0) vsource dc=0 mag=0
RI2_0_0_4 (vs2_0_0_4 vi2_0_0_4) resistor r=50
VI3_0_0_4 (vs3_0_0_4 0) vsource dc=0 mag=0
RI3_0_0_4 (vs3_0_0_4 vi3_0_0_4) resistor r=50
VI4_0_0_4 (vs4_0_0_4 0) vsource dc=0 mag=1
RI4_0_0_4 (vs4_0_0_4 vi4_0_0_4) resistor r=50
VI5_0_0_4 (vs5_0_0_4 0) vsource dc=0 mag=0
RI5_0_0_4 (vs5_0_0_4 vi5_0_0_4) resistor r=50
VI6_0_0_4 (vs6_0_0_4 0) vsource dc=0 mag=0
RI6_0_0_4 (vs6_0_0_4 vi6_0_0_4) resistor r=50
VI7_0_0_4 (vs7_0_0_4 0) vsource dc=0 mag=0
RI7_0_0_4 (vs7_0_0_4 vi7_0_0_4) resistor r=50
X0_0_4 (vdd0_0_4 0 s2_0_0_4 s1_0_0_4 s0_0_0_4 vi7_0_0_4 vi6_0_0_4 vi5_0_0_4 vi4_0_0_4 vi3_0_0_4 vi2_0_0_4 vi1_0_0_4 vi0_0_0_4 vo0_0_4) input_mux_8to1
CL0_0_4 (vo0_0_4 0) capacitor c=1p
save vo0_0_4 VDD0_0_4:p
VDD0_0_5 (vdsrc0_0_5 0) vsource dc=1.8
RVD0_0_5 (vdsrc0_0_5 vdd0_0_5) resistor r=50
VS0_0_0_5 (ss0_0_0_5 0) vsource dc=0
RS0_0_0_5 (ss0_0_0_5 s0_0_0_5) resistor r=50
VS1_0_0_5 (ss1_0_0_5 0) vsource dc=0
RS1_0_0_5 (ss1_0_0_5 s1_0_0_5) resistor r=50
VS2_0_0_5 (ss2_0_0_5 0) vsource dc=0
RS2_0_0_5 (ss2_0_0_5 s2_0_0_5) resistor r=50
VI0_0_0_5 (vs0_0_0_5 0) vsource dc=0 mag=0
RI0_0_0_5 (vs0_0_0_5 vi0_0_0_5) resistor r=50
VI1_0_0_5 (vs1_0_0_5 0) vsource dc=0 mag=0
RI1_0_0_5 (vs1_0_0_5 vi1_0_0_5) resistor r=50
VI2_0_0_5 (vs2_0_0_5 0) vsource dc=0 mag=0
RI2_0_0_5 (vs2_0_0_5 vi2_0_0_5) resistor r=50
VI3_0_0_5 (vs3_0_0_5 0) vsource dc=0 mag=0
RI3_0_0_5 (vs3_0_0_5 vi3_0_0_5) resistor r=50
VI4_0_0_5 (vs4_0_0_5 0) vsource dc=0 mag=0
RI4_0_0_5 (vs4_0_0_5 vi4_0_0_5) resistor r=50
VI5_0_0_5 (vs5_0_0_5 0) vsource dc=0 mag=1
RI5_0_0_5 (vs5_0_0_5 vi5_0_0_5) resistor r=50
VI6_0_0_5 (vs6_0_0_5 0) vsource dc=0 mag=0
RI6_0_0_5 (vs6_0_0_5 vi6_0_0_5) resistor r=50
VI7_0_0_5 (vs7_0_0_5 0) vsource dc=0 mag=0
RI7_0_0_5 (vs7_0_0_5 vi7_0_0_5) resistor r=50
X0_0_5 (vdd0_0_5 0 s2_0_0_5 s1_0_0_5 s0_0_0_5 vi7_0_0_5 vi6_0_0_5 vi5_0_0_5 vi4_0_0_5 vi3_0_0_5 vi2_0_0_5 vi1_0_0_5 vi0_0_0_5 vo0_0_5) input_mux_8to1
CL0_0_5 (vo0_0_5 0) capacitor c=1p
save vo0_0_5 VDD0_0_5:p
VDD0_0_6 (vdsrc0_0_6 0) vsource dc=1.8
RVD0_0_6 (vdsrc0_0_6 vdd0_0_6) resistor r=50
VS0_0_0_6 (ss0_0_0_6 0) vsource dc=0
RS0_0_0_6 (ss0_0_0_6 s0_0_0_6) resistor r=50
VS1_0_0_6 (ss1_0_0_6 0) vsource dc=0
RS1_0_0_6 (ss1_0_0_6 s1_0_0_6) resistor r=50
VS2_0_0_6 (ss2_0_0_6 0) vsource dc=0
RS2_0_0_6 (ss2_0_0_6 s2_0_0_6) resistor r=50
VI0_0_0_6 (vs0_0_0_6 0) vsource dc=0 mag=0
RI0_0_0_6 (vs0_0_0_6 vi0_0_0_6) resistor r=50
VI1_0_0_6 (vs1_0_0_6 0) vsource dc=0 mag=0
RI1_0_0_6 (vs1_0_0_6 vi1_0_0_6) resistor r=50
VI2_0_0_6 (vs2_0_0_6 0) vsource dc=0 mag=0
RI2_0_0_6 (vs2_0_0_6 vi2_0_0_6) resistor r=50
VI3_0_0_6 (vs3_0_0_6 0) vsource dc=0 mag=0
RI3_0_0_6 (vs3_0_0_6 vi3_0_0_6) resistor r=50
VI4_0_0_6 (vs4_0_0_6 0) vsource dc=0 mag=0
RI4_0_0_6 (vs4_0_0_6 vi4_0_0_6) resistor r=50
VI5_0_0_6 (vs5_0_0_6 0) vsource dc=0 mag=0
RI5_0_0_6 (vs5_0_0_6 vi5_0_0_6) resistor r=50
VI6_0_0_6 (vs6_0_0_6 0) vsource dc=0 mag=1
RI6_0_0_6 (vs6_0_0_6 vi6_0_0_6) resistor r=50
VI7_0_0_6 (vs7_0_0_6 0) vsource dc=0 mag=0
RI7_0_0_6 (vs7_0_0_6 vi7_0_0_6) resistor r=50
X0_0_6 (vdd0_0_6 0 s2_0_0_6 s1_0_0_6 s0_0_0_6 vi7_0_0_6 vi6_0_0_6 vi5_0_0_6 vi4_0_0_6 vi3_0_0_6 vi2_0_0_6 vi1_0_0_6 vi0_0_0_6 vo0_0_6) input_mux_8to1
CL0_0_6 (vo0_0_6 0) capacitor c=1p
save vo0_0_6 VDD0_0_6:p
VDD0_0_7 (vdsrc0_0_7 0) vsource dc=1.8
RVD0_0_7 (vdsrc0_0_7 vdd0_0_7) resistor r=50
VS0_0_0_7 (ss0_0_0_7 0) vsource dc=0
RS0_0_0_7 (ss0_0_0_7 s0_0_0_7) resistor r=50
VS1_0_0_7 (ss1_0_0_7 0) vsource dc=0
RS1_0_0_7 (ss1_0_0_7 s1_0_0_7) resistor r=50
VS2_0_0_7 (ss2_0_0_7 0) vsource dc=0
RS2_0_0_7 (ss2_0_0_7 s2_0_0_7) resistor r=50
VI0_0_0_7 (vs0_0_0_7 0) vsource dc=0 mag=0
RI0_0_0_7 (vs0_0_0_7 vi0_0_0_7) resistor r=50
VI1_0_0_7 (vs1_0_0_7 0) vsource dc=0 mag=0
RI1_0_0_7 (vs1_0_0_7 vi1_0_0_7) resistor r=50
VI2_0_0_7 (vs2_0_0_7 0) vsource dc=0 mag=0
RI2_0_0_7 (vs2_0_0_7 vi2_0_0_7) resistor r=50
VI3_0_0_7 (vs3_0_0_7 0) vsource dc=0 mag=0
RI3_0_0_7 (vs3_0_0_7 vi3_0_0_7) resistor r=50
VI4_0_0_7 (vs4_0_0_7 0) vsource dc=0 mag=0
RI4_0_0_7 (vs4_0_0_7 vi4_0_0_7) resistor r=50
VI5_0_0_7 (vs5_0_0_7 0) vsource dc=0 mag=0
RI5_0_0_7 (vs5_0_0_7 vi5_0_0_7) resistor r=50
VI6_0_0_7 (vs6_0_0_7 0) vsource dc=0 mag=0
RI6_0_0_7 (vs6_0_0_7 vi6_0_0_7) resistor r=50
VI7_0_0_7 (vs7_0_0_7 0) vsource dc=0 mag=1
RI7_0_0_7 (vs7_0_0_7 vi7_0_0_7) resistor r=50
X0_0_7 (vdd0_0_7 0 s2_0_0_7 s1_0_0_7 s0_0_0_7 vi7_0_0_7 vi6_0_0_7 vi5_0_0_7 vi4_0_0_7 vi3_0_0_7 vi2_0_0_7 vi1_0_0_7 vi0_0_0_7 vo0_0_7) input_mux_8to1
CL0_0_7 (vo0_0_7 0) capacitor c=1p
save vo0_0_7 VDD0_0_7:p
VDD0_1_0 (vdsrc0_1_0 0) vsource dc=1.8
RVD0_1_0 (vdsrc0_1_0 vdd0_1_0) resistor r=50
VS0_0_1_0 (ss0_0_1_0 0) vsource dc=1.8
RS0_0_1_0 (ss0_0_1_0 s0_0_1_0) resistor r=50
VS1_0_1_0 (ss1_0_1_0 0) vsource dc=0
RS1_0_1_0 (ss1_0_1_0 s1_0_1_0) resistor r=50
VS2_0_1_0 (ss2_0_1_0 0) vsource dc=0
RS2_0_1_0 (ss2_0_1_0 s2_0_1_0) resistor r=50
VI0_0_1_0 (vs0_0_1_0 0) vsource dc=0 mag=1
RI0_0_1_0 (vs0_0_1_0 vi0_0_1_0) resistor r=50
VI1_0_1_0 (vs1_0_1_0 0) vsource dc=0 mag=0
RI1_0_1_0 (vs1_0_1_0 vi1_0_1_0) resistor r=50
VI2_0_1_0 (vs2_0_1_0 0) vsource dc=0 mag=0
RI2_0_1_0 (vs2_0_1_0 vi2_0_1_0) resistor r=50
VI3_0_1_0 (vs3_0_1_0 0) vsource dc=0 mag=0
RI3_0_1_0 (vs3_0_1_0 vi3_0_1_0) resistor r=50
VI4_0_1_0 (vs4_0_1_0 0) vsource dc=0 mag=0
RI4_0_1_0 (vs4_0_1_0 vi4_0_1_0) resistor r=50
VI5_0_1_0 (vs5_0_1_0 0) vsource dc=0 mag=0
RI5_0_1_0 (vs5_0_1_0 vi5_0_1_0) resistor r=50
VI6_0_1_0 (vs6_0_1_0 0) vsource dc=0 mag=0
RI6_0_1_0 (vs6_0_1_0 vi6_0_1_0) resistor r=50
VI7_0_1_0 (vs7_0_1_0 0) vsource dc=0 mag=0
RI7_0_1_0 (vs7_0_1_0 vi7_0_1_0) resistor r=50
X0_1_0 (vdd0_1_0 0 s2_0_1_0 s1_0_1_0 s0_0_1_0 vi7_0_1_0 vi6_0_1_0 vi5_0_1_0 vi4_0_1_0 vi3_0_1_0 vi2_0_1_0 vi1_0_1_0 vi0_0_1_0 vo0_1_0) input_mux_8to1
CL0_1_0 (vo0_1_0 0) capacitor c=1p
save vo0_1_0 VDD0_1_0:p
VDD0_1_1 (vdsrc0_1_1 0) vsource dc=1.8
RVD0_1_1 (vdsrc0_1_1 vdd0_1_1) resistor r=50
VS0_0_1_1 (ss0_0_1_1 0) vsource dc=1.8
RS0_0_1_1 (ss0_0_1_1 s0_0_1_1) resistor r=50
VS1_0_1_1 (ss1_0_1_1 0) vsource dc=0
RS1_0_1_1 (ss1_0_1_1 s1_0_1_1) resistor r=50
VS2_0_1_1 (ss2_0_1_1 0) vsource dc=0
RS2_0_1_1 (ss2_0_1_1 s2_0_1_1) resistor r=50
VI0_0_1_1 (vs0_0_1_1 0) vsource dc=0 mag=0
RI0_0_1_1 (vs0_0_1_1 vi0_0_1_1) resistor r=50
VI1_0_1_1 (vs1_0_1_1 0) vsource dc=0 mag=1
RI1_0_1_1 (vs1_0_1_1 vi1_0_1_1) resistor r=50
VI2_0_1_1 (vs2_0_1_1 0) vsource dc=0 mag=0
RI2_0_1_1 (vs2_0_1_1 vi2_0_1_1) resistor r=50
VI3_0_1_1 (vs3_0_1_1 0) vsource dc=0 mag=0
RI3_0_1_1 (vs3_0_1_1 vi3_0_1_1) resistor r=50
VI4_0_1_1 (vs4_0_1_1 0) vsource dc=0 mag=0
RI4_0_1_1 (vs4_0_1_1 vi4_0_1_1) resistor r=50
VI5_0_1_1 (vs5_0_1_1 0) vsource dc=0 mag=0
RI5_0_1_1 (vs5_0_1_1 vi5_0_1_1) resistor r=50
VI6_0_1_1 (vs6_0_1_1 0) vsource dc=0 mag=0
RI6_0_1_1 (vs6_0_1_1 vi6_0_1_1) resistor r=50
VI7_0_1_1 (vs7_0_1_1 0) vsource dc=0 mag=0
RI7_0_1_1 (vs7_0_1_1 vi7_0_1_1) resistor r=50
X0_1_1 (vdd0_1_1 0 s2_0_1_1 s1_0_1_1 s0_0_1_1 vi7_0_1_1 vi6_0_1_1 vi5_0_1_1 vi4_0_1_1 vi3_0_1_1 vi2_0_1_1 vi1_0_1_1 vi0_0_1_1 vo0_1_1) input_mux_8to1
CL0_1_1 (vo0_1_1 0) capacitor c=1p
save vo0_1_1 VDD0_1_1:p
VDD0_1_2 (vdsrc0_1_2 0) vsource dc=1.8
RVD0_1_2 (vdsrc0_1_2 vdd0_1_2) resistor r=50
VS0_0_1_2 (ss0_0_1_2 0) vsource dc=1.8
RS0_0_1_2 (ss0_0_1_2 s0_0_1_2) resistor r=50
VS1_0_1_2 (ss1_0_1_2 0) vsource dc=0
RS1_0_1_2 (ss1_0_1_2 s1_0_1_2) resistor r=50
VS2_0_1_2 (ss2_0_1_2 0) vsource dc=0
RS2_0_1_2 (ss2_0_1_2 s2_0_1_2) resistor r=50
VI0_0_1_2 (vs0_0_1_2 0) vsource dc=0 mag=0
RI0_0_1_2 (vs0_0_1_2 vi0_0_1_2) resistor r=50
VI1_0_1_2 (vs1_0_1_2 0) vsource dc=0 mag=0
RI1_0_1_2 (vs1_0_1_2 vi1_0_1_2) resistor r=50
VI2_0_1_2 (vs2_0_1_2 0) vsource dc=0 mag=1
RI2_0_1_2 (vs2_0_1_2 vi2_0_1_2) resistor r=50
VI3_0_1_2 (vs3_0_1_2 0) vsource dc=0 mag=0
RI3_0_1_2 (vs3_0_1_2 vi3_0_1_2) resistor r=50
VI4_0_1_2 (vs4_0_1_2 0) vsource dc=0 mag=0
RI4_0_1_2 (vs4_0_1_2 vi4_0_1_2) resistor r=50
VI5_0_1_2 (vs5_0_1_2 0) vsource dc=0 mag=0
RI5_0_1_2 (vs5_0_1_2 vi5_0_1_2) resistor r=50
VI6_0_1_2 (vs6_0_1_2 0) vsource dc=0 mag=0
RI6_0_1_2 (vs6_0_1_2 vi6_0_1_2) resistor r=50
VI7_0_1_2 (vs7_0_1_2 0) vsource dc=0 mag=0
RI7_0_1_2 (vs7_0_1_2 vi7_0_1_2) resistor r=50
X0_1_2 (vdd0_1_2 0 s2_0_1_2 s1_0_1_2 s0_0_1_2 vi7_0_1_2 vi6_0_1_2 vi5_0_1_2 vi4_0_1_2 vi3_0_1_2 vi2_0_1_2 vi1_0_1_2 vi0_0_1_2 vo0_1_2) input_mux_8to1
CL0_1_2 (vo0_1_2 0) capacitor c=1p
save vo0_1_2 VDD0_1_2:p
VDD0_1_3 (vdsrc0_1_3 0) vsource dc=1.8
RVD0_1_3 (vdsrc0_1_3 vdd0_1_3) resistor r=50
VS0_0_1_3 (ss0_0_1_3 0) vsource dc=1.8
RS0_0_1_3 (ss0_0_1_3 s0_0_1_3) resistor r=50
VS1_0_1_3 (ss1_0_1_3 0) vsource dc=0
RS1_0_1_3 (ss1_0_1_3 s1_0_1_3) resistor r=50
VS2_0_1_3 (ss2_0_1_3 0) vsource dc=0
RS2_0_1_3 (ss2_0_1_3 s2_0_1_3) resistor r=50
VI0_0_1_3 (vs0_0_1_3 0) vsource dc=0 mag=0
RI0_0_1_3 (vs0_0_1_3 vi0_0_1_3) resistor r=50
VI1_0_1_3 (vs1_0_1_3 0) vsource dc=0 mag=0
RI1_0_1_3 (vs1_0_1_3 vi1_0_1_3) resistor r=50
VI2_0_1_3 (vs2_0_1_3 0) vsource dc=0 mag=0
RI2_0_1_3 (vs2_0_1_3 vi2_0_1_3) resistor r=50
VI3_0_1_3 (vs3_0_1_3 0) vsource dc=0 mag=1
RI3_0_1_3 (vs3_0_1_3 vi3_0_1_3) resistor r=50
VI4_0_1_3 (vs4_0_1_3 0) vsource dc=0 mag=0
RI4_0_1_3 (vs4_0_1_3 vi4_0_1_3) resistor r=50
VI5_0_1_3 (vs5_0_1_3 0) vsource dc=0 mag=0
RI5_0_1_3 (vs5_0_1_3 vi5_0_1_3) resistor r=50
VI6_0_1_3 (vs6_0_1_3 0) vsource dc=0 mag=0
RI6_0_1_3 (vs6_0_1_3 vi6_0_1_3) resistor r=50
VI7_0_1_3 (vs7_0_1_3 0) vsource dc=0 mag=0
RI7_0_1_3 (vs7_0_1_3 vi7_0_1_3) resistor r=50
X0_1_3 (vdd0_1_3 0 s2_0_1_3 s1_0_1_3 s0_0_1_3 vi7_0_1_3 vi6_0_1_3 vi5_0_1_3 vi4_0_1_3 vi3_0_1_3 vi2_0_1_3 vi1_0_1_3 vi0_0_1_3 vo0_1_3) input_mux_8to1
CL0_1_3 (vo0_1_3 0) capacitor c=1p
save vo0_1_3 VDD0_1_3:p
VDD0_1_4 (vdsrc0_1_4 0) vsource dc=1.8
RVD0_1_4 (vdsrc0_1_4 vdd0_1_4) resistor r=50
VS0_0_1_4 (ss0_0_1_4 0) vsource dc=1.8
RS0_0_1_4 (ss0_0_1_4 s0_0_1_4) resistor r=50
VS1_0_1_4 (ss1_0_1_4 0) vsource dc=0
RS1_0_1_4 (ss1_0_1_4 s1_0_1_4) resistor r=50
VS2_0_1_4 (ss2_0_1_4 0) vsource dc=0
RS2_0_1_4 (ss2_0_1_4 s2_0_1_4) resistor r=50
VI0_0_1_4 (vs0_0_1_4 0) vsource dc=0 mag=0
RI0_0_1_4 (vs0_0_1_4 vi0_0_1_4) resistor r=50
VI1_0_1_4 (vs1_0_1_4 0) vsource dc=0 mag=0
RI1_0_1_4 (vs1_0_1_4 vi1_0_1_4) resistor r=50
VI2_0_1_4 (vs2_0_1_4 0) vsource dc=0 mag=0
RI2_0_1_4 (vs2_0_1_4 vi2_0_1_4) resistor r=50
VI3_0_1_4 (vs3_0_1_4 0) vsource dc=0 mag=0
RI3_0_1_4 (vs3_0_1_4 vi3_0_1_4) resistor r=50
VI4_0_1_4 (vs4_0_1_4 0) vsource dc=0 mag=1
RI4_0_1_4 (vs4_0_1_4 vi4_0_1_4) resistor r=50
VI5_0_1_4 (vs5_0_1_4 0) vsource dc=0 mag=0
RI5_0_1_4 (vs5_0_1_4 vi5_0_1_4) resistor r=50
VI6_0_1_4 (vs6_0_1_4 0) vsource dc=0 mag=0
RI6_0_1_4 (vs6_0_1_4 vi6_0_1_4) resistor r=50
VI7_0_1_4 (vs7_0_1_4 0) vsource dc=0 mag=0
RI7_0_1_4 (vs7_0_1_4 vi7_0_1_4) resistor r=50
X0_1_4 (vdd0_1_4 0 s2_0_1_4 s1_0_1_4 s0_0_1_4 vi7_0_1_4 vi6_0_1_4 vi5_0_1_4 vi4_0_1_4 vi3_0_1_4 vi2_0_1_4 vi1_0_1_4 vi0_0_1_4 vo0_1_4) input_mux_8to1
CL0_1_4 (vo0_1_4 0) capacitor c=1p
save vo0_1_4 VDD0_1_4:p
VDD0_1_5 (vdsrc0_1_5 0) vsource dc=1.8
RVD0_1_5 (vdsrc0_1_5 vdd0_1_5) resistor r=50
VS0_0_1_5 (ss0_0_1_5 0) vsource dc=1.8
RS0_0_1_5 (ss0_0_1_5 s0_0_1_5) resistor r=50
VS1_0_1_5 (ss1_0_1_5 0) vsource dc=0
RS1_0_1_5 (ss1_0_1_5 s1_0_1_5) resistor r=50
VS2_0_1_5 (ss2_0_1_5 0) vsource dc=0
RS2_0_1_5 (ss2_0_1_5 s2_0_1_5) resistor r=50
VI0_0_1_5 (vs0_0_1_5 0) vsource dc=0 mag=0
RI0_0_1_5 (vs0_0_1_5 vi0_0_1_5) resistor r=50
VI1_0_1_5 (vs1_0_1_5 0) vsource dc=0 mag=0
RI1_0_1_5 (vs1_0_1_5 vi1_0_1_5) resistor r=50
VI2_0_1_5 (vs2_0_1_5 0) vsource dc=0 mag=0
RI2_0_1_5 (vs2_0_1_5 vi2_0_1_5) resistor r=50
VI3_0_1_5 (vs3_0_1_5 0) vsource dc=0 mag=0
RI3_0_1_5 (vs3_0_1_5 vi3_0_1_5) resistor r=50
VI4_0_1_5 (vs4_0_1_5 0) vsource dc=0 mag=0
RI4_0_1_5 (vs4_0_1_5 vi4_0_1_5) resistor r=50
VI5_0_1_5 (vs5_0_1_5 0) vsource dc=0 mag=1
RI5_0_1_5 (vs5_0_1_5 vi5_0_1_5) resistor r=50
VI6_0_1_5 (vs6_0_1_5 0) vsource dc=0 mag=0
RI6_0_1_5 (vs6_0_1_5 vi6_0_1_5) resistor r=50
VI7_0_1_5 (vs7_0_1_5 0) vsource dc=0 mag=0
RI7_0_1_5 (vs7_0_1_5 vi7_0_1_5) resistor r=50
X0_1_5 (vdd0_1_5 0 s2_0_1_5 s1_0_1_5 s0_0_1_5 vi7_0_1_5 vi6_0_1_5 vi5_0_1_5 vi4_0_1_5 vi3_0_1_5 vi2_0_1_5 vi1_0_1_5 vi0_0_1_5 vo0_1_5) input_mux_8to1
CL0_1_5 (vo0_1_5 0) capacitor c=1p
save vo0_1_5 VDD0_1_5:p
VDD0_1_6 (vdsrc0_1_6 0) vsource dc=1.8
RVD0_1_6 (vdsrc0_1_6 vdd0_1_6) resistor r=50
VS0_0_1_6 (ss0_0_1_6 0) vsource dc=1.8
RS0_0_1_6 (ss0_0_1_6 s0_0_1_6) resistor r=50
VS1_0_1_6 (ss1_0_1_6 0) vsource dc=0
RS1_0_1_6 (ss1_0_1_6 s1_0_1_6) resistor r=50
VS2_0_1_6 (ss2_0_1_6 0) vsource dc=0
RS2_0_1_6 (ss2_0_1_6 s2_0_1_6) resistor r=50
VI0_0_1_6 (vs0_0_1_6 0) vsource dc=0 mag=0
RI0_0_1_6 (vs0_0_1_6 vi0_0_1_6) resistor r=50
VI1_0_1_6 (vs1_0_1_6 0) vsource dc=0 mag=0
RI1_0_1_6 (vs1_0_1_6 vi1_0_1_6) resistor r=50
VI2_0_1_6 (vs2_0_1_6 0) vsource dc=0 mag=0
RI2_0_1_6 (vs2_0_1_6 vi2_0_1_6) resistor r=50
VI3_0_1_6 (vs3_0_1_6 0) vsource dc=0 mag=0
RI3_0_1_6 (vs3_0_1_6 vi3_0_1_6) resistor r=50
VI4_0_1_6 (vs4_0_1_6 0) vsource dc=0 mag=0
RI4_0_1_6 (vs4_0_1_6 vi4_0_1_6) resistor r=50
VI5_0_1_6 (vs5_0_1_6 0) vsource dc=0 mag=0
RI5_0_1_6 (vs5_0_1_6 vi5_0_1_6) resistor r=50
VI6_0_1_6 (vs6_0_1_6 0) vsource dc=0 mag=1
RI6_0_1_6 (vs6_0_1_6 vi6_0_1_6) resistor r=50
VI7_0_1_6 (vs7_0_1_6 0) vsource dc=0 mag=0
RI7_0_1_6 (vs7_0_1_6 vi7_0_1_6) resistor r=50
X0_1_6 (vdd0_1_6 0 s2_0_1_6 s1_0_1_6 s0_0_1_6 vi7_0_1_6 vi6_0_1_6 vi5_0_1_6 vi4_0_1_6 vi3_0_1_6 vi2_0_1_6 vi1_0_1_6 vi0_0_1_6 vo0_1_6) input_mux_8to1
CL0_1_6 (vo0_1_6 0) capacitor c=1p
save vo0_1_6 VDD0_1_6:p
VDD0_1_7 (vdsrc0_1_7 0) vsource dc=1.8
RVD0_1_7 (vdsrc0_1_7 vdd0_1_7) resistor r=50
VS0_0_1_7 (ss0_0_1_7 0) vsource dc=1.8
RS0_0_1_7 (ss0_0_1_7 s0_0_1_7) resistor r=50
VS1_0_1_7 (ss1_0_1_7 0) vsource dc=0
RS1_0_1_7 (ss1_0_1_7 s1_0_1_7) resistor r=50
VS2_0_1_7 (ss2_0_1_7 0) vsource dc=0
RS2_0_1_7 (ss2_0_1_7 s2_0_1_7) resistor r=50
VI0_0_1_7 (vs0_0_1_7 0) vsource dc=0 mag=0
RI0_0_1_7 (vs0_0_1_7 vi0_0_1_7) resistor r=50
VI1_0_1_7 (vs1_0_1_7 0) vsource dc=0 mag=0
RI1_0_1_7 (vs1_0_1_7 vi1_0_1_7) resistor r=50
VI2_0_1_7 (vs2_0_1_7 0) vsource dc=0 mag=0
RI2_0_1_7 (vs2_0_1_7 vi2_0_1_7) resistor r=50
VI3_0_1_7 (vs3_0_1_7 0) vsource dc=0 mag=0
RI3_0_1_7 (vs3_0_1_7 vi3_0_1_7) resistor r=50
VI4_0_1_7 (vs4_0_1_7 0) vsource dc=0 mag=0
RI4_0_1_7 (vs4_0_1_7 vi4_0_1_7) resistor r=50
VI5_0_1_7 (vs5_0_1_7 0) vsource dc=0 mag=0
RI5_0_1_7 (vs5_0_1_7 vi5_0_1_7) resistor r=50
VI6_0_1_7 (vs6_0_1_7 0) vsource dc=0 mag=0
RI6_0_1_7 (vs6_0_1_7 vi6_0_1_7) resistor r=50
VI7_0_1_7 (vs7_0_1_7 0) vsource dc=0 mag=1
RI7_0_1_7 (vs7_0_1_7 vi7_0_1_7) resistor r=50
X0_1_7 (vdd0_1_7 0 s2_0_1_7 s1_0_1_7 s0_0_1_7 vi7_0_1_7 vi6_0_1_7 vi5_0_1_7 vi4_0_1_7 vi3_0_1_7 vi2_0_1_7 vi1_0_1_7 vi0_0_1_7 vo0_1_7) input_mux_8to1
CL0_1_7 (vo0_1_7 0) capacitor c=1p
save vo0_1_7 VDD0_1_7:p
VDD0_2_0 (vdsrc0_2_0 0) vsource dc=1.8
RVD0_2_0 (vdsrc0_2_0 vdd0_2_0) resistor r=50
VS0_0_2_0 (ss0_0_2_0 0) vsource dc=0
RS0_0_2_0 (ss0_0_2_0 s0_0_2_0) resistor r=50
VS1_0_2_0 (ss1_0_2_0 0) vsource dc=1.8
RS1_0_2_0 (ss1_0_2_0 s1_0_2_0) resistor r=50
VS2_0_2_0 (ss2_0_2_0 0) vsource dc=0
RS2_0_2_0 (ss2_0_2_0 s2_0_2_0) resistor r=50
VI0_0_2_0 (vs0_0_2_0 0) vsource dc=0 mag=1
RI0_0_2_0 (vs0_0_2_0 vi0_0_2_0) resistor r=50
VI1_0_2_0 (vs1_0_2_0 0) vsource dc=0 mag=0
RI1_0_2_0 (vs1_0_2_0 vi1_0_2_0) resistor r=50
VI2_0_2_0 (vs2_0_2_0 0) vsource dc=0 mag=0
RI2_0_2_0 (vs2_0_2_0 vi2_0_2_0) resistor r=50
VI3_0_2_0 (vs3_0_2_0 0) vsource dc=0 mag=0
RI3_0_2_0 (vs3_0_2_0 vi3_0_2_0) resistor r=50
VI4_0_2_0 (vs4_0_2_0 0) vsource dc=0 mag=0
RI4_0_2_0 (vs4_0_2_0 vi4_0_2_0) resistor r=50
VI5_0_2_0 (vs5_0_2_0 0) vsource dc=0 mag=0
RI5_0_2_0 (vs5_0_2_0 vi5_0_2_0) resistor r=50
VI6_0_2_0 (vs6_0_2_0 0) vsource dc=0 mag=0
RI6_0_2_0 (vs6_0_2_0 vi6_0_2_0) resistor r=50
VI7_0_2_0 (vs7_0_2_0 0) vsource dc=0 mag=0
RI7_0_2_0 (vs7_0_2_0 vi7_0_2_0) resistor r=50
X0_2_0 (vdd0_2_0 0 s2_0_2_0 s1_0_2_0 s0_0_2_0 vi7_0_2_0 vi6_0_2_0 vi5_0_2_0 vi4_0_2_0 vi3_0_2_0 vi2_0_2_0 vi1_0_2_0 vi0_0_2_0 vo0_2_0) input_mux_8to1
CL0_2_0 (vo0_2_0 0) capacitor c=1p
save vo0_2_0 VDD0_2_0:p
VDD0_2_1 (vdsrc0_2_1 0) vsource dc=1.8
RVD0_2_1 (vdsrc0_2_1 vdd0_2_1) resistor r=50
VS0_0_2_1 (ss0_0_2_1 0) vsource dc=0
RS0_0_2_1 (ss0_0_2_1 s0_0_2_1) resistor r=50
VS1_0_2_1 (ss1_0_2_1 0) vsource dc=1.8
RS1_0_2_1 (ss1_0_2_1 s1_0_2_1) resistor r=50
VS2_0_2_1 (ss2_0_2_1 0) vsource dc=0
RS2_0_2_1 (ss2_0_2_1 s2_0_2_1) resistor r=50
VI0_0_2_1 (vs0_0_2_1 0) vsource dc=0 mag=0
RI0_0_2_1 (vs0_0_2_1 vi0_0_2_1) resistor r=50
VI1_0_2_1 (vs1_0_2_1 0) vsource dc=0 mag=1
RI1_0_2_1 (vs1_0_2_1 vi1_0_2_1) resistor r=50
VI2_0_2_1 (vs2_0_2_1 0) vsource dc=0 mag=0
RI2_0_2_1 (vs2_0_2_1 vi2_0_2_1) resistor r=50
VI3_0_2_1 (vs3_0_2_1 0) vsource dc=0 mag=0
RI3_0_2_1 (vs3_0_2_1 vi3_0_2_1) resistor r=50
VI4_0_2_1 (vs4_0_2_1 0) vsource dc=0 mag=0
RI4_0_2_1 (vs4_0_2_1 vi4_0_2_1) resistor r=50
VI5_0_2_1 (vs5_0_2_1 0) vsource dc=0 mag=0
RI5_0_2_1 (vs5_0_2_1 vi5_0_2_1) resistor r=50
VI6_0_2_1 (vs6_0_2_1 0) vsource dc=0 mag=0
RI6_0_2_1 (vs6_0_2_1 vi6_0_2_1) resistor r=50
VI7_0_2_1 (vs7_0_2_1 0) vsource dc=0 mag=0
RI7_0_2_1 (vs7_0_2_1 vi7_0_2_1) resistor r=50
X0_2_1 (vdd0_2_1 0 s2_0_2_1 s1_0_2_1 s0_0_2_1 vi7_0_2_1 vi6_0_2_1 vi5_0_2_1 vi4_0_2_1 vi3_0_2_1 vi2_0_2_1 vi1_0_2_1 vi0_0_2_1 vo0_2_1) input_mux_8to1
CL0_2_1 (vo0_2_1 0) capacitor c=1p
save vo0_2_1 VDD0_2_1:p
VDD0_2_2 (vdsrc0_2_2 0) vsource dc=1.8
RVD0_2_2 (vdsrc0_2_2 vdd0_2_2) resistor r=50
VS0_0_2_2 (ss0_0_2_2 0) vsource dc=0
RS0_0_2_2 (ss0_0_2_2 s0_0_2_2) resistor r=50
VS1_0_2_2 (ss1_0_2_2 0) vsource dc=1.8
RS1_0_2_2 (ss1_0_2_2 s1_0_2_2) resistor r=50
VS2_0_2_2 (ss2_0_2_2 0) vsource dc=0
RS2_0_2_2 (ss2_0_2_2 s2_0_2_2) resistor r=50
VI0_0_2_2 (vs0_0_2_2 0) vsource dc=0 mag=0
RI0_0_2_2 (vs0_0_2_2 vi0_0_2_2) resistor r=50
VI1_0_2_2 (vs1_0_2_2 0) vsource dc=0 mag=0
RI1_0_2_2 (vs1_0_2_2 vi1_0_2_2) resistor r=50
VI2_0_2_2 (vs2_0_2_2 0) vsource dc=0 mag=1
RI2_0_2_2 (vs2_0_2_2 vi2_0_2_2) resistor r=50
VI3_0_2_2 (vs3_0_2_2 0) vsource dc=0 mag=0
RI3_0_2_2 (vs3_0_2_2 vi3_0_2_2) resistor r=50
VI4_0_2_2 (vs4_0_2_2 0) vsource dc=0 mag=0
RI4_0_2_2 (vs4_0_2_2 vi4_0_2_2) resistor r=50
VI5_0_2_2 (vs5_0_2_2 0) vsource dc=0 mag=0
RI5_0_2_2 (vs5_0_2_2 vi5_0_2_2) resistor r=50
VI6_0_2_2 (vs6_0_2_2 0) vsource dc=0 mag=0
RI6_0_2_2 (vs6_0_2_2 vi6_0_2_2) resistor r=50
VI7_0_2_2 (vs7_0_2_2 0) vsource dc=0 mag=0
RI7_0_2_2 (vs7_0_2_2 vi7_0_2_2) resistor r=50
X0_2_2 (vdd0_2_2 0 s2_0_2_2 s1_0_2_2 s0_0_2_2 vi7_0_2_2 vi6_0_2_2 vi5_0_2_2 vi4_0_2_2 vi3_0_2_2 vi2_0_2_2 vi1_0_2_2 vi0_0_2_2 vo0_2_2) input_mux_8to1
CL0_2_2 (vo0_2_2 0) capacitor c=1p
save vo0_2_2 VDD0_2_2:p
VDD0_2_3 (vdsrc0_2_3 0) vsource dc=1.8
RVD0_2_3 (vdsrc0_2_3 vdd0_2_3) resistor r=50
VS0_0_2_3 (ss0_0_2_3 0) vsource dc=0
RS0_0_2_3 (ss0_0_2_3 s0_0_2_3) resistor r=50
VS1_0_2_3 (ss1_0_2_3 0) vsource dc=1.8
RS1_0_2_3 (ss1_0_2_3 s1_0_2_3) resistor r=50
VS2_0_2_3 (ss2_0_2_3 0) vsource dc=0
RS2_0_2_3 (ss2_0_2_3 s2_0_2_3) resistor r=50
VI0_0_2_3 (vs0_0_2_3 0) vsource dc=0 mag=0
RI0_0_2_3 (vs0_0_2_3 vi0_0_2_3) resistor r=50
VI1_0_2_3 (vs1_0_2_3 0) vsource dc=0 mag=0
RI1_0_2_3 (vs1_0_2_3 vi1_0_2_3) resistor r=50
VI2_0_2_3 (vs2_0_2_3 0) vsource dc=0 mag=0
RI2_0_2_3 (vs2_0_2_3 vi2_0_2_3) resistor r=50
VI3_0_2_3 (vs3_0_2_3 0) vsource dc=0 mag=1
RI3_0_2_3 (vs3_0_2_3 vi3_0_2_3) resistor r=50
VI4_0_2_3 (vs4_0_2_3 0) vsource dc=0 mag=0
RI4_0_2_3 (vs4_0_2_3 vi4_0_2_3) resistor r=50
VI5_0_2_3 (vs5_0_2_3 0) vsource dc=0 mag=0
RI5_0_2_3 (vs5_0_2_3 vi5_0_2_3) resistor r=50
VI6_0_2_3 (vs6_0_2_3 0) vsource dc=0 mag=0
RI6_0_2_3 (vs6_0_2_3 vi6_0_2_3) resistor r=50
VI7_0_2_3 (vs7_0_2_3 0) vsource dc=0 mag=0
RI7_0_2_3 (vs7_0_2_3 vi7_0_2_3) resistor r=50
X0_2_3 (vdd0_2_3 0 s2_0_2_3 s1_0_2_3 s0_0_2_3 vi7_0_2_3 vi6_0_2_3 vi5_0_2_3 vi4_0_2_3 vi3_0_2_3 vi2_0_2_3 vi1_0_2_3 vi0_0_2_3 vo0_2_3) input_mux_8to1
CL0_2_3 (vo0_2_3 0) capacitor c=1p
save vo0_2_3 VDD0_2_3:p
VDD0_2_4 (vdsrc0_2_4 0) vsource dc=1.8
RVD0_2_4 (vdsrc0_2_4 vdd0_2_4) resistor r=50
VS0_0_2_4 (ss0_0_2_4 0) vsource dc=0
RS0_0_2_4 (ss0_0_2_4 s0_0_2_4) resistor r=50
VS1_0_2_4 (ss1_0_2_4 0) vsource dc=1.8
RS1_0_2_4 (ss1_0_2_4 s1_0_2_4) resistor r=50
VS2_0_2_4 (ss2_0_2_4 0) vsource dc=0
RS2_0_2_4 (ss2_0_2_4 s2_0_2_4) resistor r=50
VI0_0_2_4 (vs0_0_2_4 0) vsource dc=0 mag=0
RI0_0_2_4 (vs0_0_2_4 vi0_0_2_4) resistor r=50
VI1_0_2_4 (vs1_0_2_4 0) vsource dc=0 mag=0
RI1_0_2_4 (vs1_0_2_4 vi1_0_2_4) resistor r=50
VI2_0_2_4 (vs2_0_2_4 0) vsource dc=0 mag=0
RI2_0_2_4 (vs2_0_2_4 vi2_0_2_4) resistor r=50
VI3_0_2_4 (vs3_0_2_4 0) vsource dc=0 mag=0
RI3_0_2_4 (vs3_0_2_4 vi3_0_2_4) resistor r=50
VI4_0_2_4 (vs4_0_2_4 0) vsource dc=0 mag=1
RI4_0_2_4 (vs4_0_2_4 vi4_0_2_4) resistor r=50
VI5_0_2_4 (vs5_0_2_4 0) vsource dc=0 mag=0
RI5_0_2_4 (vs5_0_2_4 vi5_0_2_4) resistor r=50
VI6_0_2_4 (vs6_0_2_4 0) vsource dc=0 mag=0
RI6_0_2_4 (vs6_0_2_4 vi6_0_2_4) resistor r=50
VI7_0_2_4 (vs7_0_2_4 0) vsource dc=0 mag=0
RI7_0_2_4 (vs7_0_2_4 vi7_0_2_4) resistor r=50
X0_2_4 (vdd0_2_4 0 s2_0_2_4 s1_0_2_4 s0_0_2_4 vi7_0_2_4 vi6_0_2_4 vi5_0_2_4 vi4_0_2_4 vi3_0_2_4 vi2_0_2_4 vi1_0_2_4 vi0_0_2_4 vo0_2_4) input_mux_8to1
CL0_2_4 (vo0_2_4 0) capacitor c=1p
save vo0_2_4 VDD0_2_4:p
VDD0_2_5 (vdsrc0_2_5 0) vsource dc=1.8
RVD0_2_5 (vdsrc0_2_5 vdd0_2_5) resistor r=50
VS0_0_2_5 (ss0_0_2_5 0) vsource dc=0
RS0_0_2_5 (ss0_0_2_5 s0_0_2_5) resistor r=50
VS1_0_2_5 (ss1_0_2_5 0) vsource dc=1.8
RS1_0_2_5 (ss1_0_2_5 s1_0_2_5) resistor r=50
VS2_0_2_5 (ss2_0_2_5 0) vsource dc=0
RS2_0_2_5 (ss2_0_2_5 s2_0_2_5) resistor r=50
VI0_0_2_5 (vs0_0_2_5 0) vsource dc=0 mag=0
RI0_0_2_5 (vs0_0_2_5 vi0_0_2_5) resistor r=50
VI1_0_2_5 (vs1_0_2_5 0) vsource dc=0 mag=0
RI1_0_2_5 (vs1_0_2_5 vi1_0_2_5) resistor r=50
VI2_0_2_5 (vs2_0_2_5 0) vsource dc=0 mag=0
RI2_0_2_5 (vs2_0_2_5 vi2_0_2_5) resistor r=50
VI3_0_2_5 (vs3_0_2_5 0) vsource dc=0 mag=0
RI3_0_2_5 (vs3_0_2_5 vi3_0_2_5) resistor r=50
VI4_0_2_5 (vs4_0_2_5 0) vsource dc=0 mag=0
RI4_0_2_5 (vs4_0_2_5 vi4_0_2_5) resistor r=50
VI5_0_2_5 (vs5_0_2_5 0) vsource dc=0 mag=1
RI5_0_2_5 (vs5_0_2_5 vi5_0_2_5) resistor r=50
VI6_0_2_5 (vs6_0_2_5 0) vsource dc=0 mag=0
RI6_0_2_5 (vs6_0_2_5 vi6_0_2_5) resistor r=50
VI7_0_2_5 (vs7_0_2_5 0) vsource dc=0 mag=0
RI7_0_2_5 (vs7_0_2_5 vi7_0_2_5) resistor r=50
X0_2_5 (vdd0_2_5 0 s2_0_2_5 s1_0_2_5 s0_0_2_5 vi7_0_2_5 vi6_0_2_5 vi5_0_2_5 vi4_0_2_5 vi3_0_2_5 vi2_0_2_5 vi1_0_2_5 vi0_0_2_5 vo0_2_5) input_mux_8to1
CL0_2_5 (vo0_2_5 0) capacitor c=1p
save vo0_2_5 VDD0_2_5:p
VDD0_2_6 (vdsrc0_2_6 0) vsource dc=1.8
RVD0_2_6 (vdsrc0_2_6 vdd0_2_6) resistor r=50
VS0_0_2_6 (ss0_0_2_6 0) vsource dc=0
RS0_0_2_6 (ss0_0_2_6 s0_0_2_6) resistor r=50
VS1_0_2_6 (ss1_0_2_6 0) vsource dc=1.8
RS1_0_2_6 (ss1_0_2_6 s1_0_2_6) resistor r=50
VS2_0_2_6 (ss2_0_2_6 0) vsource dc=0
RS2_0_2_6 (ss2_0_2_6 s2_0_2_6) resistor r=50
VI0_0_2_6 (vs0_0_2_6 0) vsource dc=0 mag=0
RI0_0_2_6 (vs0_0_2_6 vi0_0_2_6) resistor r=50
VI1_0_2_6 (vs1_0_2_6 0) vsource dc=0 mag=0
RI1_0_2_6 (vs1_0_2_6 vi1_0_2_6) resistor r=50
VI2_0_2_6 (vs2_0_2_6 0) vsource dc=0 mag=0
RI2_0_2_6 (vs2_0_2_6 vi2_0_2_6) resistor r=50
VI3_0_2_6 (vs3_0_2_6 0) vsource dc=0 mag=0
RI3_0_2_6 (vs3_0_2_6 vi3_0_2_6) resistor r=50
VI4_0_2_6 (vs4_0_2_6 0) vsource dc=0 mag=0
RI4_0_2_6 (vs4_0_2_6 vi4_0_2_6) resistor r=50
VI5_0_2_6 (vs5_0_2_6 0) vsource dc=0 mag=0
RI5_0_2_6 (vs5_0_2_6 vi5_0_2_6) resistor r=50
VI6_0_2_6 (vs6_0_2_6 0) vsource dc=0 mag=1
RI6_0_2_6 (vs6_0_2_6 vi6_0_2_6) resistor r=50
VI7_0_2_6 (vs7_0_2_6 0) vsource dc=0 mag=0
RI7_0_2_6 (vs7_0_2_6 vi7_0_2_6) resistor r=50
X0_2_6 (vdd0_2_6 0 s2_0_2_6 s1_0_2_6 s0_0_2_6 vi7_0_2_6 vi6_0_2_6 vi5_0_2_6 vi4_0_2_6 vi3_0_2_6 vi2_0_2_6 vi1_0_2_6 vi0_0_2_6 vo0_2_6) input_mux_8to1
CL0_2_6 (vo0_2_6 0) capacitor c=1p
save vo0_2_6 VDD0_2_6:p
VDD0_2_7 (vdsrc0_2_7 0) vsource dc=1.8
RVD0_2_7 (vdsrc0_2_7 vdd0_2_7) resistor r=50
VS0_0_2_7 (ss0_0_2_7 0) vsource dc=0
RS0_0_2_7 (ss0_0_2_7 s0_0_2_7) resistor r=50
VS1_0_2_7 (ss1_0_2_7 0) vsource dc=1.8
RS1_0_2_7 (ss1_0_2_7 s1_0_2_7) resistor r=50
VS2_0_2_7 (ss2_0_2_7 0) vsource dc=0
RS2_0_2_7 (ss2_0_2_7 s2_0_2_7) resistor r=50
VI0_0_2_7 (vs0_0_2_7 0) vsource dc=0 mag=0
RI0_0_2_7 (vs0_0_2_7 vi0_0_2_7) resistor r=50
VI1_0_2_7 (vs1_0_2_7 0) vsource dc=0 mag=0
RI1_0_2_7 (vs1_0_2_7 vi1_0_2_7) resistor r=50
VI2_0_2_7 (vs2_0_2_7 0) vsource dc=0 mag=0
RI2_0_2_7 (vs2_0_2_7 vi2_0_2_7) resistor r=50
VI3_0_2_7 (vs3_0_2_7 0) vsource dc=0 mag=0
RI3_0_2_7 (vs3_0_2_7 vi3_0_2_7) resistor r=50
VI4_0_2_7 (vs4_0_2_7 0) vsource dc=0 mag=0
RI4_0_2_7 (vs4_0_2_7 vi4_0_2_7) resistor r=50
VI5_0_2_7 (vs5_0_2_7 0) vsource dc=0 mag=0
RI5_0_2_7 (vs5_0_2_7 vi5_0_2_7) resistor r=50
VI6_0_2_7 (vs6_0_2_7 0) vsource dc=0 mag=0
RI6_0_2_7 (vs6_0_2_7 vi6_0_2_7) resistor r=50
VI7_0_2_7 (vs7_0_2_7 0) vsource dc=0 mag=1
RI7_0_2_7 (vs7_0_2_7 vi7_0_2_7) resistor r=50
X0_2_7 (vdd0_2_7 0 s2_0_2_7 s1_0_2_7 s0_0_2_7 vi7_0_2_7 vi6_0_2_7 vi5_0_2_7 vi4_0_2_7 vi3_0_2_7 vi2_0_2_7 vi1_0_2_7 vi0_0_2_7 vo0_2_7) input_mux_8to1
CL0_2_7 (vo0_2_7 0) capacitor c=1p
save vo0_2_7 VDD0_2_7:p
VDD0_3_0 (vdsrc0_3_0 0) vsource dc=1.8
RVD0_3_0 (vdsrc0_3_0 vdd0_3_0) resistor r=50
VS0_0_3_0 (ss0_0_3_0 0) vsource dc=1.8
RS0_0_3_0 (ss0_0_3_0 s0_0_3_0) resistor r=50
VS1_0_3_0 (ss1_0_3_0 0) vsource dc=1.8
RS1_0_3_0 (ss1_0_3_0 s1_0_3_0) resistor r=50
VS2_0_3_0 (ss2_0_3_0 0) vsource dc=0
RS2_0_3_0 (ss2_0_3_0 s2_0_3_0) resistor r=50
VI0_0_3_0 (vs0_0_3_0 0) vsource dc=0 mag=1
RI0_0_3_0 (vs0_0_3_0 vi0_0_3_0) resistor r=50
VI1_0_3_0 (vs1_0_3_0 0) vsource dc=0 mag=0
RI1_0_3_0 (vs1_0_3_0 vi1_0_3_0) resistor r=50
VI2_0_3_0 (vs2_0_3_0 0) vsource dc=0 mag=0
RI2_0_3_0 (vs2_0_3_0 vi2_0_3_0) resistor r=50
VI3_0_3_0 (vs3_0_3_0 0) vsource dc=0 mag=0
RI3_0_3_0 (vs3_0_3_0 vi3_0_3_0) resistor r=50
VI4_0_3_0 (vs4_0_3_0 0) vsource dc=0 mag=0
RI4_0_3_0 (vs4_0_3_0 vi4_0_3_0) resistor r=50
VI5_0_3_0 (vs5_0_3_0 0) vsource dc=0 mag=0
RI5_0_3_0 (vs5_0_3_0 vi5_0_3_0) resistor r=50
VI6_0_3_0 (vs6_0_3_0 0) vsource dc=0 mag=0
RI6_0_3_0 (vs6_0_3_0 vi6_0_3_0) resistor r=50
VI7_0_3_0 (vs7_0_3_0 0) vsource dc=0 mag=0
RI7_0_3_0 (vs7_0_3_0 vi7_0_3_0) resistor r=50
X0_3_0 (vdd0_3_0 0 s2_0_3_0 s1_0_3_0 s0_0_3_0 vi7_0_3_0 vi6_0_3_0 vi5_0_3_0 vi4_0_3_0 vi3_0_3_0 vi2_0_3_0 vi1_0_3_0 vi0_0_3_0 vo0_3_0) input_mux_8to1
CL0_3_0 (vo0_3_0 0) capacitor c=1p
save vo0_3_0 VDD0_3_0:p
VDD0_3_1 (vdsrc0_3_1 0) vsource dc=1.8
RVD0_3_1 (vdsrc0_3_1 vdd0_3_1) resistor r=50
VS0_0_3_1 (ss0_0_3_1 0) vsource dc=1.8
RS0_0_3_1 (ss0_0_3_1 s0_0_3_1) resistor r=50
VS1_0_3_1 (ss1_0_3_1 0) vsource dc=1.8
RS1_0_3_1 (ss1_0_3_1 s1_0_3_1) resistor r=50
VS2_0_3_1 (ss2_0_3_1 0) vsource dc=0
RS2_0_3_1 (ss2_0_3_1 s2_0_3_1) resistor r=50
VI0_0_3_1 (vs0_0_3_1 0) vsource dc=0 mag=0
RI0_0_3_1 (vs0_0_3_1 vi0_0_3_1) resistor r=50
VI1_0_3_1 (vs1_0_3_1 0) vsource dc=0 mag=1
RI1_0_3_1 (vs1_0_3_1 vi1_0_3_1) resistor r=50
VI2_0_3_1 (vs2_0_3_1 0) vsource dc=0 mag=0
RI2_0_3_1 (vs2_0_3_1 vi2_0_3_1) resistor r=50
VI3_0_3_1 (vs3_0_3_1 0) vsource dc=0 mag=0
RI3_0_3_1 (vs3_0_3_1 vi3_0_3_1) resistor r=50
VI4_0_3_1 (vs4_0_3_1 0) vsource dc=0 mag=0
RI4_0_3_1 (vs4_0_3_1 vi4_0_3_1) resistor r=50
VI5_0_3_1 (vs5_0_3_1 0) vsource dc=0 mag=0
RI5_0_3_1 (vs5_0_3_1 vi5_0_3_1) resistor r=50
VI6_0_3_1 (vs6_0_3_1 0) vsource dc=0 mag=0
RI6_0_3_1 (vs6_0_3_1 vi6_0_3_1) resistor r=50
VI7_0_3_1 (vs7_0_3_1 0) vsource dc=0 mag=0
RI7_0_3_1 (vs7_0_3_1 vi7_0_3_1) resistor r=50
X0_3_1 (vdd0_3_1 0 s2_0_3_1 s1_0_3_1 s0_0_3_1 vi7_0_3_1 vi6_0_3_1 vi5_0_3_1 vi4_0_3_1 vi3_0_3_1 vi2_0_3_1 vi1_0_3_1 vi0_0_3_1 vo0_3_1) input_mux_8to1
CL0_3_1 (vo0_3_1 0) capacitor c=1p
save vo0_3_1 VDD0_3_1:p
VDD0_3_2 (vdsrc0_3_2 0) vsource dc=1.8
RVD0_3_2 (vdsrc0_3_2 vdd0_3_2) resistor r=50
VS0_0_3_2 (ss0_0_3_2 0) vsource dc=1.8
RS0_0_3_2 (ss0_0_3_2 s0_0_3_2) resistor r=50
VS1_0_3_2 (ss1_0_3_2 0) vsource dc=1.8
RS1_0_3_2 (ss1_0_3_2 s1_0_3_2) resistor r=50
VS2_0_3_2 (ss2_0_3_2 0) vsource dc=0
RS2_0_3_2 (ss2_0_3_2 s2_0_3_2) resistor r=50
VI0_0_3_2 (vs0_0_3_2 0) vsource dc=0 mag=0
RI0_0_3_2 (vs0_0_3_2 vi0_0_3_2) resistor r=50
VI1_0_3_2 (vs1_0_3_2 0) vsource dc=0 mag=0
RI1_0_3_2 (vs1_0_3_2 vi1_0_3_2) resistor r=50
VI2_0_3_2 (vs2_0_3_2 0) vsource dc=0 mag=1
RI2_0_3_2 (vs2_0_3_2 vi2_0_3_2) resistor r=50
VI3_0_3_2 (vs3_0_3_2 0) vsource dc=0 mag=0
RI3_0_3_2 (vs3_0_3_2 vi3_0_3_2) resistor r=50
VI4_0_3_2 (vs4_0_3_2 0) vsource dc=0 mag=0
RI4_0_3_2 (vs4_0_3_2 vi4_0_3_2) resistor r=50
VI5_0_3_2 (vs5_0_3_2 0) vsource dc=0 mag=0
RI5_0_3_2 (vs5_0_3_2 vi5_0_3_2) resistor r=50
VI6_0_3_2 (vs6_0_3_2 0) vsource dc=0 mag=0
RI6_0_3_2 (vs6_0_3_2 vi6_0_3_2) resistor r=50
VI7_0_3_2 (vs7_0_3_2 0) vsource dc=0 mag=0
RI7_0_3_2 (vs7_0_3_2 vi7_0_3_2) resistor r=50
X0_3_2 (vdd0_3_2 0 s2_0_3_2 s1_0_3_2 s0_0_3_2 vi7_0_3_2 vi6_0_3_2 vi5_0_3_2 vi4_0_3_2 vi3_0_3_2 vi2_0_3_2 vi1_0_3_2 vi0_0_3_2 vo0_3_2) input_mux_8to1
CL0_3_2 (vo0_3_2 0) capacitor c=1p
save vo0_3_2 VDD0_3_2:p
VDD0_3_3 (vdsrc0_3_3 0) vsource dc=1.8
RVD0_3_3 (vdsrc0_3_3 vdd0_3_3) resistor r=50
VS0_0_3_3 (ss0_0_3_3 0) vsource dc=1.8
RS0_0_3_3 (ss0_0_3_3 s0_0_3_3) resistor r=50
VS1_0_3_3 (ss1_0_3_3 0) vsource dc=1.8
RS1_0_3_3 (ss1_0_3_3 s1_0_3_3) resistor r=50
VS2_0_3_3 (ss2_0_3_3 0) vsource dc=0
RS2_0_3_3 (ss2_0_3_3 s2_0_3_3) resistor r=50
VI0_0_3_3 (vs0_0_3_3 0) vsource dc=0 mag=0
RI0_0_3_3 (vs0_0_3_3 vi0_0_3_3) resistor r=50
VI1_0_3_3 (vs1_0_3_3 0) vsource dc=0 mag=0
RI1_0_3_3 (vs1_0_3_3 vi1_0_3_3) resistor r=50
VI2_0_3_3 (vs2_0_3_3 0) vsource dc=0 mag=0
RI2_0_3_3 (vs2_0_3_3 vi2_0_3_3) resistor r=50
VI3_0_3_3 (vs3_0_3_3 0) vsource dc=0 mag=1
RI3_0_3_3 (vs3_0_3_3 vi3_0_3_3) resistor r=50
VI4_0_3_3 (vs4_0_3_3 0) vsource dc=0 mag=0
RI4_0_3_3 (vs4_0_3_3 vi4_0_3_3) resistor r=50
VI5_0_3_3 (vs5_0_3_3 0) vsource dc=0 mag=0
RI5_0_3_3 (vs5_0_3_3 vi5_0_3_3) resistor r=50
VI6_0_3_3 (vs6_0_3_3 0) vsource dc=0 mag=0
RI6_0_3_3 (vs6_0_3_3 vi6_0_3_3) resistor r=50
VI7_0_3_3 (vs7_0_3_3 0) vsource dc=0 mag=0
RI7_0_3_3 (vs7_0_3_3 vi7_0_3_3) resistor r=50
X0_3_3 (vdd0_3_3 0 s2_0_3_3 s1_0_3_3 s0_0_3_3 vi7_0_3_3 vi6_0_3_3 vi5_0_3_3 vi4_0_3_3 vi3_0_3_3 vi2_0_3_3 vi1_0_3_3 vi0_0_3_3 vo0_3_3) input_mux_8to1
CL0_3_3 (vo0_3_3 0) capacitor c=1p
save vo0_3_3 VDD0_3_3:p
VDD0_3_4 (vdsrc0_3_4 0) vsource dc=1.8
RVD0_3_4 (vdsrc0_3_4 vdd0_3_4) resistor r=50
VS0_0_3_4 (ss0_0_3_4 0) vsource dc=1.8
RS0_0_3_4 (ss0_0_3_4 s0_0_3_4) resistor r=50
VS1_0_3_4 (ss1_0_3_4 0) vsource dc=1.8
RS1_0_3_4 (ss1_0_3_4 s1_0_3_4) resistor r=50
VS2_0_3_4 (ss2_0_3_4 0) vsource dc=0
RS2_0_3_4 (ss2_0_3_4 s2_0_3_4) resistor r=50
VI0_0_3_4 (vs0_0_3_4 0) vsource dc=0 mag=0
RI0_0_3_4 (vs0_0_3_4 vi0_0_3_4) resistor r=50
VI1_0_3_4 (vs1_0_3_4 0) vsource dc=0 mag=0
RI1_0_3_4 (vs1_0_3_4 vi1_0_3_4) resistor r=50
VI2_0_3_4 (vs2_0_3_4 0) vsource dc=0 mag=0
RI2_0_3_4 (vs2_0_3_4 vi2_0_3_4) resistor r=50
VI3_0_3_4 (vs3_0_3_4 0) vsource dc=0 mag=0
RI3_0_3_4 (vs3_0_3_4 vi3_0_3_4) resistor r=50
VI4_0_3_4 (vs4_0_3_4 0) vsource dc=0 mag=1
RI4_0_3_4 (vs4_0_3_4 vi4_0_3_4) resistor r=50
VI5_0_3_4 (vs5_0_3_4 0) vsource dc=0 mag=0
RI5_0_3_4 (vs5_0_3_4 vi5_0_3_4) resistor r=50
VI6_0_3_4 (vs6_0_3_4 0) vsource dc=0 mag=0
RI6_0_3_4 (vs6_0_3_4 vi6_0_3_4) resistor r=50
VI7_0_3_4 (vs7_0_3_4 0) vsource dc=0 mag=0
RI7_0_3_4 (vs7_0_3_4 vi7_0_3_4) resistor r=50
X0_3_4 (vdd0_3_4 0 s2_0_3_4 s1_0_3_4 s0_0_3_4 vi7_0_3_4 vi6_0_3_4 vi5_0_3_4 vi4_0_3_4 vi3_0_3_4 vi2_0_3_4 vi1_0_3_4 vi0_0_3_4 vo0_3_4) input_mux_8to1
CL0_3_4 (vo0_3_4 0) capacitor c=1p
save vo0_3_4 VDD0_3_4:p
VDD0_3_5 (vdsrc0_3_5 0) vsource dc=1.8
RVD0_3_5 (vdsrc0_3_5 vdd0_3_5) resistor r=50
VS0_0_3_5 (ss0_0_3_5 0) vsource dc=1.8
RS0_0_3_5 (ss0_0_3_5 s0_0_3_5) resistor r=50
VS1_0_3_5 (ss1_0_3_5 0) vsource dc=1.8
RS1_0_3_5 (ss1_0_3_5 s1_0_3_5) resistor r=50
VS2_0_3_5 (ss2_0_3_5 0) vsource dc=0
RS2_0_3_5 (ss2_0_3_5 s2_0_3_5) resistor r=50
VI0_0_3_5 (vs0_0_3_5 0) vsource dc=0 mag=0
RI0_0_3_5 (vs0_0_3_5 vi0_0_3_5) resistor r=50
VI1_0_3_5 (vs1_0_3_5 0) vsource dc=0 mag=0
RI1_0_3_5 (vs1_0_3_5 vi1_0_3_5) resistor r=50
VI2_0_3_5 (vs2_0_3_5 0) vsource dc=0 mag=0
RI2_0_3_5 (vs2_0_3_5 vi2_0_3_5) resistor r=50
VI3_0_3_5 (vs3_0_3_5 0) vsource dc=0 mag=0
RI3_0_3_5 (vs3_0_3_5 vi3_0_3_5) resistor r=50
VI4_0_3_5 (vs4_0_3_5 0) vsource dc=0 mag=0
RI4_0_3_5 (vs4_0_3_5 vi4_0_3_5) resistor r=50
VI5_0_3_5 (vs5_0_3_5 0) vsource dc=0 mag=1
RI5_0_3_5 (vs5_0_3_5 vi5_0_3_5) resistor r=50
VI6_0_3_5 (vs6_0_3_5 0) vsource dc=0 mag=0
RI6_0_3_5 (vs6_0_3_5 vi6_0_3_5) resistor r=50
VI7_0_3_5 (vs7_0_3_5 0) vsource dc=0 mag=0
RI7_0_3_5 (vs7_0_3_5 vi7_0_3_5) resistor r=50
X0_3_5 (vdd0_3_5 0 s2_0_3_5 s1_0_3_5 s0_0_3_5 vi7_0_3_5 vi6_0_3_5 vi5_0_3_5 vi4_0_3_5 vi3_0_3_5 vi2_0_3_5 vi1_0_3_5 vi0_0_3_5 vo0_3_5) input_mux_8to1
CL0_3_5 (vo0_3_5 0) capacitor c=1p
save vo0_3_5 VDD0_3_5:p
VDD0_3_6 (vdsrc0_3_6 0) vsource dc=1.8
RVD0_3_6 (vdsrc0_3_6 vdd0_3_6) resistor r=50
VS0_0_3_6 (ss0_0_3_6 0) vsource dc=1.8
RS0_0_3_6 (ss0_0_3_6 s0_0_3_6) resistor r=50
VS1_0_3_6 (ss1_0_3_6 0) vsource dc=1.8
RS1_0_3_6 (ss1_0_3_6 s1_0_3_6) resistor r=50
VS2_0_3_6 (ss2_0_3_6 0) vsource dc=0
RS2_0_3_6 (ss2_0_3_6 s2_0_3_6) resistor r=50
VI0_0_3_6 (vs0_0_3_6 0) vsource dc=0 mag=0
RI0_0_3_6 (vs0_0_3_6 vi0_0_3_6) resistor r=50
VI1_0_3_6 (vs1_0_3_6 0) vsource dc=0 mag=0
RI1_0_3_6 (vs1_0_3_6 vi1_0_3_6) resistor r=50
VI2_0_3_6 (vs2_0_3_6 0) vsource dc=0 mag=0
RI2_0_3_6 (vs2_0_3_6 vi2_0_3_6) resistor r=50
VI3_0_3_6 (vs3_0_3_6 0) vsource dc=0 mag=0
RI3_0_3_6 (vs3_0_3_6 vi3_0_3_6) resistor r=50
VI4_0_3_6 (vs4_0_3_6 0) vsource dc=0 mag=0
RI4_0_3_6 (vs4_0_3_6 vi4_0_3_6) resistor r=50
VI5_0_3_6 (vs5_0_3_6 0) vsource dc=0 mag=0
RI5_0_3_6 (vs5_0_3_6 vi5_0_3_6) resistor r=50
VI6_0_3_6 (vs6_0_3_6 0) vsource dc=0 mag=1
RI6_0_3_6 (vs6_0_3_6 vi6_0_3_6) resistor r=50
VI7_0_3_6 (vs7_0_3_6 0) vsource dc=0 mag=0
RI7_0_3_6 (vs7_0_3_6 vi7_0_3_6) resistor r=50
X0_3_6 (vdd0_3_6 0 s2_0_3_6 s1_0_3_6 s0_0_3_6 vi7_0_3_6 vi6_0_3_6 vi5_0_3_6 vi4_0_3_6 vi3_0_3_6 vi2_0_3_6 vi1_0_3_6 vi0_0_3_6 vo0_3_6) input_mux_8to1
CL0_3_6 (vo0_3_6 0) capacitor c=1p
save vo0_3_6 VDD0_3_6:p
VDD0_3_7 (vdsrc0_3_7 0) vsource dc=1.8
RVD0_3_7 (vdsrc0_3_7 vdd0_3_7) resistor r=50
VS0_0_3_7 (ss0_0_3_7 0) vsource dc=1.8
RS0_0_3_7 (ss0_0_3_7 s0_0_3_7) resistor r=50
VS1_0_3_7 (ss1_0_3_7 0) vsource dc=1.8
RS1_0_3_7 (ss1_0_3_7 s1_0_3_7) resistor r=50
VS2_0_3_7 (ss2_0_3_7 0) vsource dc=0
RS2_0_3_7 (ss2_0_3_7 s2_0_3_7) resistor r=50
VI0_0_3_7 (vs0_0_3_7 0) vsource dc=0 mag=0
RI0_0_3_7 (vs0_0_3_7 vi0_0_3_7) resistor r=50
VI1_0_3_7 (vs1_0_3_7 0) vsource dc=0 mag=0
RI1_0_3_7 (vs1_0_3_7 vi1_0_3_7) resistor r=50
VI2_0_3_7 (vs2_0_3_7 0) vsource dc=0 mag=0
RI2_0_3_7 (vs2_0_3_7 vi2_0_3_7) resistor r=50
VI3_0_3_7 (vs3_0_3_7 0) vsource dc=0 mag=0
RI3_0_3_7 (vs3_0_3_7 vi3_0_3_7) resistor r=50
VI4_0_3_7 (vs4_0_3_7 0) vsource dc=0 mag=0
RI4_0_3_7 (vs4_0_3_7 vi4_0_3_7) resistor r=50
VI5_0_3_7 (vs5_0_3_7 0) vsource dc=0 mag=0
RI5_0_3_7 (vs5_0_3_7 vi5_0_3_7) resistor r=50
VI6_0_3_7 (vs6_0_3_7 0) vsource dc=0 mag=0
RI6_0_3_7 (vs6_0_3_7 vi6_0_3_7) resistor r=50
VI7_0_3_7 (vs7_0_3_7 0) vsource dc=0 mag=1
RI7_0_3_7 (vs7_0_3_7 vi7_0_3_7) resistor r=50
X0_3_7 (vdd0_3_7 0 s2_0_3_7 s1_0_3_7 s0_0_3_7 vi7_0_3_7 vi6_0_3_7 vi5_0_3_7 vi4_0_3_7 vi3_0_3_7 vi2_0_3_7 vi1_0_3_7 vi0_0_3_7 vo0_3_7) input_mux_8to1
CL0_3_7 (vo0_3_7 0) capacitor c=1p
save vo0_3_7 VDD0_3_7:p
VDD0_4_0 (vdsrc0_4_0 0) vsource dc=1.8
RVD0_4_0 (vdsrc0_4_0 vdd0_4_0) resistor r=50
VS0_0_4_0 (ss0_0_4_0 0) vsource dc=0
RS0_0_4_0 (ss0_0_4_0 s0_0_4_0) resistor r=50
VS1_0_4_0 (ss1_0_4_0 0) vsource dc=0
RS1_0_4_0 (ss1_0_4_0 s1_0_4_0) resistor r=50
VS2_0_4_0 (ss2_0_4_0 0) vsource dc=1.8
RS2_0_4_0 (ss2_0_4_0 s2_0_4_0) resistor r=50
VI0_0_4_0 (vs0_0_4_0 0) vsource dc=0 mag=1
RI0_0_4_0 (vs0_0_4_0 vi0_0_4_0) resistor r=50
VI1_0_4_0 (vs1_0_4_0 0) vsource dc=0 mag=0
RI1_0_4_0 (vs1_0_4_0 vi1_0_4_0) resistor r=50
VI2_0_4_0 (vs2_0_4_0 0) vsource dc=0 mag=0
RI2_0_4_0 (vs2_0_4_0 vi2_0_4_0) resistor r=50
VI3_0_4_0 (vs3_0_4_0 0) vsource dc=0 mag=0
RI3_0_4_0 (vs3_0_4_0 vi3_0_4_0) resistor r=50
VI4_0_4_0 (vs4_0_4_0 0) vsource dc=0 mag=0
RI4_0_4_0 (vs4_0_4_0 vi4_0_4_0) resistor r=50
VI5_0_4_0 (vs5_0_4_0 0) vsource dc=0 mag=0
RI5_0_4_0 (vs5_0_4_0 vi5_0_4_0) resistor r=50
VI6_0_4_0 (vs6_0_4_0 0) vsource dc=0 mag=0
RI6_0_4_0 (vs6_0_4_0 vi6_0_4_0) resistor r=50
VI7_0_4_0 (vs7_0_4_0 0) vsource dc=0 mag=0
RI7_0_4_0 (vs7_0_4_0 vi7_0_4_0) resistor r=50
X0_4_0 (vdd0_4_0 0 s2_0_4_0 s1_0_4_0 s0_0_4_0 vi7_0_4_0 vi6_0_4_0 vi5_0_4_0 vi4_0_4_0 vi3_0_4_0 vi2_0_4_0 vi1_0_4_0 vi0_0_4_0 vo0_4_0) input_mux_8to1
CL0_4_0 (vo0_4_0 0) capacitor c=1p
save vo0_4_0 VDD0_4_0:p
VDD0_4_1 (vdsrc0_4_1 0) vsource dc=1.8
RVD0_4_1 (vdsrc0_4_1 vdd0_4_1) resistor r=50
VS0_0_4_1 (ss0_0_4_1 0) vsource dc=0
RS0_0_4_1 (ss0_0_4_1 s0_0_4_1) resistor r=50
VS1_0_4_1 (ss1_0_4_1 0) vsource dc=0
RS1_0_4_1 (ss1_0_4_1 s1_0_4_1) resistor r=50
VS2_0_4_1 (ss2_0_4_1 0) vsource dc=1.8
RS2_0_4_1 (ss2_0_4_1 s2_0_4_1) resistor r=50
VI0_0_4_1 (vs0_0_4_1 0) vsource dc=0 mag=0
RI0_0_4_1 (vs0_0_4_1 vi0_0_4_1) resistor r=50
VI1_0_4_1 (vs1_0_4_1 0) vsource dc=0 mag=1
RI1_0_4_1 (vs1_0_4_1 vi1_0_4_1) resistor r=50
VI2_0_4_1 (vs2_0_4_1 0) vsource dc=0 mag=0
RI2_0_4_1 (vs2_0_4_1 vi2_0_4_1) resistor r=50
VI3_0_4_1 (vs3_0_4_1 0) vsource dc=0 mag=0
RI3_0_4_1 (vs3_0_4_1 vi3_0_4_1) resistor r=50
VI4_0_4_1 (vs4_0_4_1 0) vsource dc=0 mag=0
RI4_0_4_1 (vs4_0_4_1 vi4_0_4_1) resistor r=50
VI5_0_4_1 (vs5_0_4_1 0) vsource dc=0 mag=0
RI5_0_4_1 (vs5_0_4_1 vi5_0_4_1) resistor r=50
VI6_0_4_1 (vs6_0_4_1 0) vsource dc=0 mag=0
RI6_0_4_1 (vs6_0_4_1 vi6_0_4_1) resistor r=50
VI7_0_4_1 (vs7_0_4_1 0) vsource dc=0 mag=0
RI7_0_4_1 (vs7_0_4_1 vi7_0_4_1) resistor r=50
X0_4_1 (vdd0_4_1 0 s2_0_4_1 s1_0_4_1 s0_0_4_1 vi7_0_4_1 vi6_0_4_1 vi5_0_4_1 vi4_0_4_1 vi3_0_4_1 vi2_0_4_1 vi1_0_4_1 vi0_0_4_1 vo0_4_1) input_mux_8to1
CL0_4_1 (vo0_4_1 0) capacitor c=1p
save vo0_4_1 VDD0_4_1:p
VDD0_4_2 (vdsrc0_4_2 0) vsource dc=1.8
RVD0_4_2 (vdsrc0_4_2 vdd0_4_2) resistor r=50
VS0_0_4_2 (ss0_0_4_2 0) vsource dc=0
RS0_0_4_2 (ss0_0_4_2 s0_0_4_2) resistor r=50
VS1_0_4_2 (ss1_0_4_2 0) vsource dc=0
RS1_0_4_2 (ss1_0_4_2 s1_0_4_2) resistor r=50
VS2_0_4_2 (ss2_0_4_2 0) vsource dc=1.8
RS2_0_4_2 (ss2_0_4_2 s2_0_4_2) resistor r=50
VI0_0_4_2 (vs0_0_4_2 0) vsource dc=0 mag=0
RI0_0_4_2 (vs0_0_4_2 vi0_0_4_2) resistor r=50
VI1_0_4_2 (vs1_0_4_2 0) vsource dc=0 mag=0
RI1_0_4_2 (vs1_0_4_2 vi1_0_4_2) resistor r=50
VI2_0_4_2 (vs2_0_4_2 0) vsource dc=0 mag=1
RI2_0_4_2 (vs2_0_4_2 vi2_0_4_2) resistor r=50
VI3_0_4_2 (vs3_0_4_2 0) vsource dc=0 mag=0
RI3_0_4_2 (vs3_0_4_2 vi3_0_4_2) resistor r=50
VI4_0_4_2 (vs4_0_4_2 0) vsource dc=0 mag=0
RI4_0_4_2 (vs4_0_4_2 vi4_0_4_2) resistor r=50
VI5_0_4_2 (vs5_0_4_2 0) vsource dc=0 mag=0
RI5_0_4_2 (vs5_0_4_2 vi5_0_4_2) resistor r=50
VI6_0_4_2 (vs6_0_4_2 0) vsource dc=0 mag=0
RI6_0_4_2 (vs6_0_4_2 vi6_0_4_2) resistor r=50
VI7_0_4_2 (vs7_0_4_2 0) vsource dc=0 mag=0
RI7_0_4_2 (vs7_0_4_2 vi7_0_4_2) resistor r=50
X0_4_2 (vdd0_4_2 0 s2_0_4_2 s1_0_4_2 s0_0_4_2 vi7_0_4_2 vi6_0_4_2 vi5_0_4_2 vi4_0_4_2 vi3_0_4_2 vi2_0_4_2 vi1_0_4_2 vi0_0_4_2 vo0_4_2) input_mux_8to1
CL0_4_2 (vo0_4_2 0) capacitor c=1p
save vo0_4_2 VDD0_4_2:p
VDD0_4_3 (vdsrc0_4_3 0) vsource dc=1.8
RVD0_4_3 (vdsrc0_4_3 vdd0_4_3) resistor r=50
VS0_0_4_3 (ss0_0_4_3 0) vsource dc=0
RS0_0_4_3 (ss0_0_4_3 s0_0_4_3) resistor r=50
VS1_0_4_3 (ss1_0_4_3 0) vsource dc=0
RS1_0_4_3 (ss1_0_4_3 s1_0_4_3) resistor r=50
VS2_0_4_3 (ss2_0_4_3 0) vsource dc=1.8
RS2_0_4_3 (ss2_0_4_3 s2_0_4_3) resistor r=50
VI0_0_4_3 (vs0_0_4_3 0) vsource dc=0 mag=0
RI0_0_4_3 (vs0_0_4_3 vi0_0_4_3) resistor r=50
VI1_0_4_3 (vs1_0_4_3 0) vsource dc=0 mag=0
RI1_0_4_3 (vs1_0_4_3 vi1_0_4_3) resistor r=50
VI2_0_4_3 (vs2_0_4_3 0) vsource dc=0 mag=0
RI2_0_4_3 (vs2_0_4_3 vi2_0_4_3) resistor r=50
VI3_0_4_3 (vs3_0_4_3 0) vsource dc=0 mag=1
RI3_0_4_3 (vs3_0_4_3 vi3_0_4_3) resistor r=50
VI4_0_4_3 (vs4_0_4_3 0) vsource dc=0 mag=0
RI4_0_4_3 (vs4_0_4_3 vi4_0_4_3) resistor r=50
VI5_0_4_3 (vs5_0_4_3 0) vsource dc=0 mag=0
RI5_0_4_3 (vs5_0_4_3 vi5_0_4_3) resistor r=50
VI6_0_4_3 (vs6_0_4_3 0) vsource dc=0 mag=0
RI6_0_4_3 (vs6_0_4_3 vi6_0_4_3) resistor r=50
VI7_0_4_3 (vs7_0_4_3 0) vsource dc=0 mag=0
RI7_0_4_3 (vs7_0_4_3 vi7_0_4_3) resistor r=50
X0_4_3 (vdd0_4_3 0 s2_0_4_3 s1_0_4_3 s0_0_4_3 vi7_0_4_3 vi6_0_4_3 vi5_0_4_3 vi4_0_4_3 vi3_0_4_3 vi2_0_4_3 vi1_0_4_3 vi0_0_4_3 vo0_4_3) input_mux_8to1
CL0_4_3 (vo0_4_3 0) capacitor c=1p
save vo0_4_3 VDD0_4_3:p
VDD0_4_4 (vdsrc0_4_4 0) vsource dc=1.8
RVD0_4_4 (vdsrc0_4_4 vdd0_4_4) resistor r=50
VS0_0_4_4 (ss0_0_4_4 0) vsource dc=0
RS0_0_4_4 (ss0_0_4_4 s0_0_4_4) resistor r=50
VS1_0_4_4 (ss1_0_4_4 0) vsource dc=0
RS1_0_4_4 (ss1_0_4_4 s1_0_4_4) resistor r=50
VS2_0_4_4 (ss2_0_4_4 0) vsource dc=1.8
RS2_0_4_4 (ss2_0_4_4 s2_0_4_4) resistor r=50
VI0_0_4_4 (vs0_0_4_4 0) vsource dc=0 mag=0
RI0_0_4_4 (vs0_0_4_4 vi0_0_4_4) resistor r=50
VI1_0_4_4 (vs1_0_4_4 0) vsource dc=0 mag=0
RI1_0_4_4 (vs1_0_4_4 vi1_0_4_4) resistor r=50
VI2_0_4_4 (vs2_0_4_4 0) vsource dc=0 mag=0
RI2_0_4_4 (vs2_0_4_4 vi2_0_4_4) resistor r=50
VI3_0_4_4 (vs3_0_4_4 0) vsource dc=0 mag=0
RI3_0_4_4 (vs3_0_4_4 vi3_0_4_4) resistor r=50
VI4_0_4_4 (vs4_0_4_4 0) vsource dc=0 mag=1
RI4_0_4_4 (vs4_0_4_4 vi4_0_4_4) resistor r=50
VI5_0_4_4 (vs5_0_4_4 0) vsource dc=0 mag=0
RI5_0_4_4 (vs5_0_4_4 vi5_0_4_4) resistor r=50
VI6_0_4_4 (vs6_0_4_4 0) vsource dc=0 mag=0
RI6_0_4_4 (vs6_0_4_4 vi6_0_4_4) resistor r=50
VI7_0_4_4 (vs7_0_4_4 0) vsource dc=0 mag=0
RI7_0_4_4 (vs7_0_4_4 vi7_0_4_4) resistor r=50
X0_4_4 (vdd0_4_4 0 s2_0_4_4 s1_0_4_4 s0_0_4_4 vi7_0_4_4 vi6_0_4_4 vi5_0_4_4 vi4_0_4_4 vi3_0_4_4 vi2_0_4_4 vi1_0_4_4 vi0_0_4_4 vo0_4_4) input_mux_8to1
CL0_4_4 (vo0_4_4 0) capacitor c=1p
save vo0_4_4 VDD0_4_4:p
VDD0_4_5 (vdsrc0_4_5 0) vsource dc=1.8
RVD0_4_5 (vdsrc0_4_5 vdd0_4_5) resistor r=50
VS0_0_4_5 (ss0_0_4_5 0) vsource dc=0
RS0_0_4_5 (ss0_0_4_5 s0_0_4_5) resistor r=50
VS1_0_4_5 (ss1_0_4_5 0) vsource dc=0
RS1_0_4_5 (ss1_0_4_5 s1_0_4_5) resistor r=50
VS2_0_4_5 (ss2_0_4_5 0) vsource dc=1.8
RS2_0_4_5 (ss2_0_4_5 s2_0_4_5) resistor r=50
VI0_0_4_5 (vs0_0_4_5 0) vsource dc=0 mag=0
RI0_0_4_5 (vs0_0_4_5 vi0_0_4_5) resistor r=50
VI1_0_4_5 (vs1_0_4_5 0) vsource dc=0 mag=0
RI1_0_4_5 (vs1_0_4_5 vi1_0_4_5) resistor r=50
VI2_0_4_5 (vs2_0_4_5 0) vsource dc=0 mag=0
RI2_0_4_5 (vs2_0_4_5 vi2_0_4_5) resistor r=50
VI3_0_4_5 (vs3_0_4_5 0) vsource dc=0 mag=0
RI3_0_4_5 (vs3_0_4_5 vi3_0_4_5) resistor r=50
VI4_0_4_5 (vs4_0_4_5 0) vsource dc=0 mag=0
RI4_0_4_5 (vs4_0_4_5 vi4_0_4_5) resistor r=50
VI5_0_4_5 (vs5_0_4_5 0) vsource dc=0 mag=1
RI5_0_4_5 (vs5_0_4_5 vi5_0_4_5) resistor r=50
VI6_0_4_5 (vs6_0_4_5 0) vsource dc=0 mag=0
RI6_0_4_5 (vs6_0_4_5 vi6_0_4_5) resistor r=50
VI7_0_4_5 (vs7_0_4_5 0) vsource dc=0 mag=0
RI7_0_4_5 (vs7_0_4_5 vi7_0_4_5) resistor r=50
X0_4_5 (vdd0_4_5 0 s2_0_4_5 s1_0_4_5 s0_0_4_5 vi7_0_4_5 vi6_0_4_5 vi5_0_4_5 vi4_0_4_5 vi3_0_4_5 vi2_0_4_5 vi1_0_4_5 vi0_0_4_5 vo0_4_5) input_mux_8to1
CL0_4_5 (vo0_4_5 0) capacitor c=1p
save vo0_4_5 VDD0_4_5:p
VDD0_4_6 (vdsrc0_4_6 0) vsource dc=1.8
RVD0_4_6 (vdsrc0_4_6 vdd0_4_6) resistor r=50
VS0_0_4_6 (ss0_0_4_6 0) vsource dc=0
RS0_0_4_6 (ss0_0_4_6 s0_0_4_6) resistor r=50
VS1_0_4_6 (ss1_0_4_6 0) vsource dc=0
RS1_0_4_6 (ss1_0_4_6 s1_0_4_6) resistor r=50
VS2_0_4_6 (ss2_0_4_6 0) vsource dc=1.8
RS2_0_4_6 (ss2_0_4_6 s2_0_4_6) resistor r=50
VI0_0_4_6 (vs0_0_4_6 0) vsource dc=0 mag=0
RI0_0_4_6 (vs0_0_4_6 vi0_0_4_6) resistor r=50
VI1_0_4_6 (vs1_0_4_6 0) vsource dc=0 mag=0
RI1_0_4_6 (vs1_0_4_6 vi1_0_4_6) resistor r=50
VI2_0_4_6 (vs2_0_4_6 0) vsource dc=0 mag=0
RI2_0_4_6 (vs2_0_4_6 vi2_0_4_6) resistor r=50
VI3_0_4_6 (vs3_0_4_6 0) vsource dc=0 mag=0
RI3_0_4_6 (vs3_0_4_6 vi3_0_4_6) resistor r=50
VI4_0_4_6 (vs4_0_4_6 0) vsource dc=0 mag=0
RI4_0_4_6 (vs4_0_4_6 vi4_0_4_6) resistor r=50
VI5_0_4_6 (vs5_0_4_6 0) vsource dc=0 mag=0
RI5_0_4_6 (vs5_0_4_6 vi5_0_4_6) resistor r=50
VI6_0_4_6 (vs6_0_4_6 0) vsource dc=0 mag=1
RI6_0_4_6 (vs6_0_4_6 vi6_0_4_6) resistor r=50
VI7_0_4_6 (vs7_0_4_6 0) vsource dc=0 mag=0
RI7_0_4_6 (vs7_0_4_6 vi7_0_4_6) resistor r=50
X0_4_6 (vdd0_4_6 0 s2_0_4_6 s1_0_4_6 s0_0_4_6 vi7_0_4_6 vi6_0_4_6 vi5_0_4_6 vi4_0_4_6 vi3_0_4_6 vi2_0_4_6 vi1_0_4_6 vi0_0_4_6 vo0_4_6) input_mux_8to1
CL0_4_6 (vo0_4_6 0) capacitor c=1p
save vo0_4_6 VDD0_4_6:p
VDD0_4_7 (vdsrc0_4_7 0) vsource dc=1.8
RVD0_4_7 (vdsrc0_4_7 vdd0_4_7) resistor r=50
VS0_0_4_7 (ss0_0_4_7 0) vsource dc=0
RS0_0_4_7 (ss0_0_4_7 s0_0_4_7) resistor r=50
VS1_0_4_7 (ss1_0_4_7 0) vsource dc=0
RS1_0_4_7 (ss1_0_4_7 s1_0_4_7) resistor r=50
VS2_0_4_7 (ss2_0_4_7 0) vsource dc=1.8
RS2_0_4_7 (ss2_0_4_7 s2_0_4_7) resistor r=50
VI0_0_4_7 (vs0_0_4_7 0) vsource dc=0 mag=0
RI0_0_4_7 (vs0_0_4_7 vi0_0_4_7) resistor r=50
VI1_0_4_7 (vs1_0_4_7 0) vsource dc=0 mag=0
RI1_0_4_7 (vs1_0_4_7 vi1_0_4_7) resistor r=50
VI2_0_4_7 (vs2_0_4_7 0) vsource dc=0 mag=0
RI2_0_4_7 (vs2_0_4_7 vi2_0_4_7) resistor r=50
VI3_0_4_7 (vs3_0_4_7 0) vsource dc=0 mag=0
RI3_0_4_7 (vs3_0_4_7 vi3_0_4_7) resistor r=50
VI4_0_4_7 (vs4_0_4_7 0) vsource dc=0 mag=0
RI4_0_4_7 (vs4_0_4_7 vi4_0_4_7) resistor r=50
VI5_0_4_7 (vs5_0_4_7 0) vsource dc=0 mag=0
RI5_0_4_7 (vs5_0_4_7 vi5_0_4_7) resistor r=50
VI6_0_4_7 (vs6_0_4_7 0) vsource dc=0 mag=0
RI6_0_4_7 (vs6_0_4_7 vi6_0_4_7) resistor r=50
VI7_0_4_7 (vs7_0_4_7 0) vsource dc=0 mag=1
RI7_0_4_7 (vs7_0_4_7 vi7_0_4_7) resistor r=50
X0_4_7 (vdd0_4_7 0 s2_0_4_7 s1_0_4_7 s0_0_4_7 vi7_0_4_7 vi6_0_4_7 vi5_0_4_7 vi4_0_4_7 vi3_0_4_7 vi2_0_4_7 vi1_0_4_7 vi0_0_4_7 vo0_4_7) input_mux_8to1
CL0_4_7 (vo0_4_7 0) capacitor c=1p
save vo0_4_7 VDD0_4_7:p
VDD0_5_0 (vdsrc0_5_0 0) vsource dc=1.8
RVD0_5_0 (vdsrc0_5_0 vdd0_5_0) resistor r=50
VS0_0_5_0 (ss0_0_5_0 0) vsource dc=1.8
RS0_0_5_0 (ss0_0_5_0 s0_0_5_0) resistor r=50
VS1_0_5_0 (ss1_0_5_0 0) vsource dc=0
RS1_0_5_0 (ss1_0_5_0 s1_0_5_0) resistor r=50
VS2_0_5_0 (ss2_0_5_0 0) vsource dc=1.8
RS2_0_5_0 (ss2_0_5_0 s2_0_5_0) resistor r=50
VI0_0_5_0 (vs0_0_5_0 0) vsource dc=0 mag=1
RI0_0_5_0 (vs0_0_5_0 vi0_0_5_0) resistor r=50
VI1_0_5_0 (vs1_0_5_0 0) vsource dc=0 mag=0
RI1_0_5_0 (vs1_0_5_0 vi1_0_5_0) resistor r=50
VI2_0_5_0 (vs2_0_5_0 0) vsource dc=0 mag=0
RI2_0_5_0 (vs2_0_5_0 vi2_0_5_0) resistor r=50
VI3_0_5_0 (vs3_0_5_0 0) vsource dc=0 mag=0
RI3_0_5_0 (vs3_0_5_0 vi3_0_5_0) resistor r=50
VI4_0_5_0 (vs4_0_5_0 0) vsource dc=0 mag=0
RI4_0_5_0 (vs4_0_5_0 vi4_0_5_0) resistor r=50
VI5_0_5_0 (vs5_0_5_0 0) vsource dc=0 mag=0
RI5_0_5_0 (vs5_0_5_0 vi5_0_5_0) resistor r=50
VI6_0_5_0 (vs6_0_5_0 0) vsource dc=0 mag=0
RI6_0_5_0 (vs6_0_5_0 vi6_0_5_0) resistor r=50
VI7_0_5_0 (vs7_0_5_0 0) vsource dc=0 mag=0
RI7_0_5_0 (vs7_0_5_0 vi7_0_5_0) resistor r=50
X0_5_0 (vdd0_5_0 0 s2_0_5_0 s1_0_5_0 s0_0_5_0 vi7_0_5_0 vi6_0_5_0 vi5_0_5_0 vi4_0_5_0 vi3_0_5_0 vi2_0_5_0 vi1_0_5_0 vi0_0_5_0 vo0_5_0) input_mux_8to1
CL0_5_0 (vo0_5_0 0) capacitor c=1p
save vo0_5_0 VDD0_5_0:p
VDD0_5_1 (vdsrc0_5_1 0) vsource dc=1.8
RVD0_5_1 (vdsrc0_5_1 vdd0_5_1) resistor r=50
VS0_0_5_1 (ss0_0_5_1 0) vsource dc=1.8
RS0_0_5_1 (ss0_0_5_1 s0_0_5_1) resistor r=50
VS1_0_5_1 (ss1_0_5_1 0) vsource dc=0
RS1_0_5_1 (ss1_0_5_1 s1_0_5_1) resistor r=50
VS2_0_5_1 (ss2_0_5_1 0) vsource dc=1.8
RS2_0_5_1 (ss2_0_5_1 s2_0_5_1) resistor r=50
VI0_0_5_1 (vs0_0_5_1 0) vsource dc=0 mag=0
RI0_0_5_1 (vs0_0_5_1 vi0_0_5_1) resistor r=50
VI1_0_5_1 (vs1_0_5_1 0) vsource dc=0 mag=1
RI1_0_5_1 (vs1_0_5_1 vi1_0_5_1) resistor r=50
VI2_0_5_1 (vs2_0_5_1 0) vsource dc=0 mag=0
RI2_0_5_1 (vs2_0_5_1 vi2_0_5_1) resistor r=50
VI3_0_5_1 (vs3_0_5_1 0) vsource dc=0 mag=0
RI3_0_5_1 (vs3_0_5_1 vi3_0_5_1) resistor r=50
VI4_0_5_1 (vs4_0_5_1 0) vsource dc=0 mag=0
RI4_0_5_1 (vs4_0_5_1 vi4_0_5_1) resistor r=50
VI5_0_5_1 (vs5_0_5_1 0) vsource dc=0 mag=0
RI5_0_5_1 (vs5_0_5_1 vi5_0_5_1) resistor r=50
VI6_0_5_1 (vs6_0_5_1 0) vsource dc=0 mag=0
RI6_0_5_1 (vs6_0_5_1 vi6_0_5_1) resistor r=50
VI7_0_5_1 (vs7_0_5_1 0) vsource dc=0 mag=0
RI7_0_5_1 (vs7_0_5_1 vi7_0_5_1) resistor r=50
X0_5_1 (vdd0_5_1 0 s2_0_5_1 s1_0_5_1 s0_0_5_1 vi7_0_5_1 vi6_0_5_1 vi5_0_5_1 vi4_0_5_1 vi3_0_5_1 vi2_0_5_1 vi1_0_5_1 vi0_0_5_1 vo0_5_1) input_mux_8to1
CL0_5_1 (vo0_5_1 0) capacitor c=1p
save vo0_5_1 VDD0_5_1:p
VDD0_5_2 (vdsrc0_5_2 0) vsource dc=1.8
RVD0_5_2 (vdsrc0_5_2 vdd0_5_2) resistor r=50
VS0_0_5_2 (ss0_0_5_2 0) vsource dc=1.8
RS0_0_5_2 (ss0_0_5_2 s0_0_5_2) resistor r=50
VS1_0_5_2 (ss1_0_5_2 0) vsource dc=0
RS1_0_5_2 (ss1_0_5_2 s1_0_5_2) resistor r=50
VS2_0_5_2 (ss2_0_5_2 0) vsource dc=1.8
RS2_0_5_2 (ss2_0_5_2 s2_0_5_2) resistor r=50
VI0_0_5_2 (vs0_0_5_2 0) vsource dc=0 mag=0
RI0_0_5_2 (vs0_0_5_2 vi0_0_5_2) resistor r=50
VI1_0_5_2 (vs1_0_5_2 0) vsource dc=0 mag=0
RI1_0_5_2 (vs1_0_5_2 vi1_0_5_2) resistor r=50
VI2_0_5_2 (vs2_0_5_2 0) vsource dc=0 mag=1
RI2_0_5_2 (vs2_0_5_2 vi2_0_5_2) resistor r=50
VI3_0_5_2 (vs3_0_5_2 0) vsource dc=0 mag=0
RI3_0_5_2 (vs3_0_5_2 vi3_0_5_2) resistor r=50
VI4_0_5_2 (vs4_0_5_2 0) vsource dc=0 mag=0
RI4_0_5_2 (vs4_0_5_2 vi4_0_5_2) resistor r=50
VI5_0_5_2 (vs5_0_5_2 0) vsource dc=0 mag=0
RI5_0_5_2 (vs5_0_5_2 vi5_0_5_2) resistor r=50
VI6_0_5_2 (vs6_0_5_2 0) vsource dc=0 mag=0
RI6_0_5_2 (vs6_0_5_2 vi6_0_5_2) resistor r=50
VI7_0_5_2 (vs7_0_5_2 0) vsource dc=0 mag=0
RI7_0_5_2 (vs7_0_5_2 vi7_0_5_2) resistor r=50
X0_5_2 (vdd0_5_2 0 s2_0_5_2 s1_0_5_2 s0_0_5_2 vi7_0_5_2 vi6_0_5_2 vi5_0_5_2 vi4_0_5_2 vi3_0_5_2 vi2_0_5_2 vi1_0_5_2 vi0_0_5_2 vo0_5_2) input_mux_8to1
CL0_5_2 (vo0_5_2 0) capacitor c=1p
save vo0_5_2 VDD0_5_2:p
VDD0_5_3 (vdsrc0_5_3 0) vsource dc=1.8
RVD0_5_3 (vdsrc0_5_3 vdd0_5_3) resistor r=50
VS0_0_5_3 (ss0_0_5_3 0) vsource dc=1.8
RS0_0_5_3 (ss0_0_5_3 s0_0_5_3) resistor r=50
VS1_0_5_3 (ss1_0_5_3 0) vsource dc=0
RS1_0_5_3 (ss1_0_5_3 s1_0_5_3) resistor r=50
VS2_0_5_3 (ss2_0_5_3 0) vsource dc=1.8
RS2_0_5_3 (ss2_0_5_3 s2_0_5_3) resistor r=50
VI0_0_5_3 (vs0_0_5_3 0) vsource dc=0 mag=0
RI0_0_5_3 (vs0_0_5_3 vi0_0_5_3) resistor r=50
VI1_0_5_3 (vs1_0_5_3 0) vsource dc=0 mag=0
RI1_0_5_3 (vs1_0_5_3 vi1_0_5_3) resistor r=50
VI2_0_5_3 (vs2_0_5_3 0) vsource dc=0 mag=0
RI2_0_5_3 (vs2_0_5_3 vi2_0_5_3) resistor r=50
VI3_0_5_3 (vs3_0_5_3 0) vsource dc=0 mag=1
RI3_0_5_3 (vs3_0_5_3 vi3_0_5_3) resistor r=50
VI4_0_5_3 (vs4_0_5_3 0) vsource dc=0 mag=0
RI4_0_5_3 (vs4_0_5_3 vi4_0_5_3) resistor r=50
VI5_0_5_3 (vs5_0_5_3 0) vsource dc=0 mag=0
RI5_0_5_3 (vs5_0_5_3 vi5_0_5_3) resistor r=50
VI6_0_5_3 (vs6_0_5_3 0) vsource dc=0 mag=0
RI6_0_5_3 (vs6_0_5_3 vi6_0_5_3) resistor r=50
VI7_0_5_3 (vs7_0_5_3 0) vsource dc=0 mag=0
RI7_0_5_3 (vs7_0_5_3 vi7_0_5_3) resistor r=50
X0_5_3 (vdd0_5_3 0 s2_0_5_3 s1_0_5_3 s0_0_5_3 vi7_0_5_3 vi6_0_5_3 vi5_0_5_3 vi4_0_5_3 vi3_0_5_3 vi2_0_5_3 vi1_0_5_3 vi0_0_5_3 vo0_5_3) input_mux_8to1
CL0_5_3 (vo0_5_3 0) capacitor c=1p
save vo0_5_3 VDD0_5_3:p
VDD0_5_4 (vdsrc0_5_4 0) vsource dc=1.8
RVD0_5_4 (vdsrc0_5_4 vdd0_5_4) resistor r=50
VS0_0_5_4 (ss0_0_5_4 0) vsource dc=1.8
RS0_0_5_4 (ss0_0_5_4 s0_0_5_4) resistor r=50
VS1_0_5_4 (ss1_0_5_4 0) vsource dc=0
RS1_0_5_4 (ss1_0_5_4 s1_0_5_4) resistor r=50
VS2_0_5_4 (ss2_0_5_4 0) vsource dc=1.8
RS2_0_5_4 (ss2_0_5_4 s2_0_5_4) resistor r=50
VI0_0_5_4 (vs0_0_5_4 0) vsource dc=0 mag=0
RI0_0_5_4 (vs0_0_5_4 vi0_0_5_4) resistor r=50
VI1_0_5_4 (vs1_0_5_4 0) vsource dc=0 mag=0
RI1_0_5_4 (vs1_0_5_4 vi1_0_5_4) resistor r=50
VI2_0_5_4 (vs2_0_5_4 0) vsource dc=0 mag=0
RI2_0_5_4 (vs2_0_5_4 vi2_0_5_4) resistor r=50
VI3_0_5_4 (vs3_0_5_4 0) vsource dc=0 mag=0
RI3_0_5_4 (vs3_0_5_4 vi3_0_5_4) resistor r=50
VI4_0_5_4 (vs4_0_5_4 0) vsource dc=0 mag=1
RI4_0_5_4 (vs4_0_5_4 vi4_0_5_4) resistor r=50
VI5_0_5_4 (vs5_0_5_4 0) vsource dc=0 mag=0
RI5_0_5_4 (vs5_0_5_4 vi5_0_5_4) resistor r=50
VI6_0_5_4 (vs6_0_5_4 0) vsource dc=0 mag=0
RI6_0_5_4 (vs6_0_5_4 vi6_0_5_4) resistor r=50
VI7_0_5_4 (vs7_0_5_4 0) vsource dc=0 mag=0
RI7_0_5_4 (vs7_0_5_4 vi7_0_5_4) resistor r=50
X0_5_4 (vdd0_5_4 0 s2_0_5_4 s1_0_5_4 s0_0_5_4 vi7_0_5_4 vi6_0_5_4 vi5_0_5_4 vi4_0_5_4 vi3_0_5_4 vi2_0_5_4 vi1_0_5_4 vi0_0_5_4 vo0_5_4) input_mux_8to1
CL0_5_4 (vo0_5_4 0) capacitor c=1p
save vo0_5_4 VDD0_5_4:p
VDD0_5_5 (vdsrc0_5_5 0) vsource dc=1.8
RVD0_5_5 (vdsrc0_5_5 vdd0_5_5) resistor r=50
VS0_0_5_5 (ss0_0_5_5 0) vsource dc=1.8
RS0_0_5_5 (ss0_0_5_5 s0_0_5_5) resistor r=50
VS1_0_5_5 (ss1_0_5_5 0) vsource dc=0
RS1_0_5_5 (ss1_0_5_5 s1_0_5_5) resistor r=50
VS2_0_5_5 (ss2_0_5_5 0) vsource dc=1.8
RS2_0_5_5 (ss2_0_5_5 s2_0_5_5) resistor r=50
VI0_0_5_5 (vs0_0_5_5 0) vsource dc=0 mag=0
RI0_0_5_5 (vs0_0_5_5 vi0_0_5_5) resistor r=50
VI1_0_5_5 (vs1_0_5_5 0) vsource dc=0 mag=0
RI1_0_5_5 (vs1_0_5_5 vi1_0_5_5) resistor r=50
VI2_0_5_5 (vs2_0_5_5 0) vsource dc=0 mag=0
RI2_0_5_5 (vs2_0_5_5 vi2_0_5_5) resistor r=50
VI3_0_5_5 (vs3_0_5_5 0) vsource dc=0 mag=0
RI3_0_5_5 (vs3_0_5_5 vi3_0_5_5) resistor r=50
VI4_0_5_5 (vs4_0_5_5 0) vsource dc=0 mag=0
RI4_0_5_5 (vs4_0_5_5 vi4_0_5_5) resistor r=50
VI5_0_5_5 (vs5_0_5_5 0) vsource dc=0 mag=1
RI5_0_5_5 (vs5_0_5_5 vi5_0_5_5) resistor r=50
VI6_0_5_5 (vs6_0_5_5 0) vsource dc=0 mag=0
RI6_0_5_5 (vs6_0_5_5 vi6_0_5_5) resistor r=50
VI7_0_5_5 (vs7_0_5_5 0) vsource dc=0 mag=0
RI7_0_5_5 (vs7_0_5_5 vi7_0_5_5) resistor r=50
X0_5_5 (vdd0_5_5 0 s2_0_5_5 s1_0_5_5 s0_0_5_5 vi7_0_5_5 vi6_0_5_5 vi5_0_5_5 vi4_0_5_5 vi3_0_5_5 vi2_0_5_5 vi1_0_5_5 vi0_0_5_5 vo0_5_5) input_mux_8to1
CL0_5_5 (vo0_5_5 0) capacitor c=1p
save vo0_5_5 VDD0_5_5:p
VDD0_5_6 (vdsrc0_5_6 0) vsource dc=1.8
RVD0_5_6 (vdsrc0_5_6 vdd0_5_6) resistor r=50
VS0_0_5_6 (ss0_0_5_6 0) vsource dc=1.8
RS0_0_5_6 (ss0_0_5_6 s0_0_5_6) resistor r=50
VS1_0_5_6 (ss1_0_5_6 0) vsource dc=0
RS1_0_5_6 (ss1_0_5_6 s1_0_5_6) resistor r=50
VS2_0_5_6 (ss2_0_5_6 0) vsource dc=1.8
RS2_0_5_6 (ss2_0_5_6 s2_0_5_6) resistor r=50
VI0_0_5_6 (vs0_0_5_6 0) vsource dc=0 mag=0
RI0_0_5_6 (vs0_0_5_6 vi0_0_5_6) resistor r=50
VI1_0_5_6 (vs1_0_5_6 0) vsource dc=0 mag=0
RI1_0_5_6 (vs1_0_5_6 vi1_0_5_6) resistor r=50
VI2_0_5_6 (vs2_0_5_6 0) vsource dc=0 mag=0
RI2_0_5_6 (vs2_0_5_6 vi2_0_5_6) resistor r=50
VI3_0_5_6 (vs3_0_5_6 0) vsource dc=0 mag=0
RI3_0_5_6 (vs3_0_5_6 vi3_0_5_6) resistor r=50
VI4_0_5_6 (vs4_0_5_6 0) vsource dc=0 mag=0
RI4_0_5_6 (vs4_0_5_6 vi4_0_5_6) resistor r=50
VI5_0_5_6 (vs5_0_5_6 0) vsource dc=0 mag=0
RI5_0_5_6 (vs5_0_5_6 vi5_0_5_6) resistor r=50
VI6_0_5_6 (vs6_0_5_6 0) vsource dc=0 mag=1
RI6_0_5_6 (vs6_0_5_6 vi6_0_5_6) resistor r=50
VI7_0_5_6 (vs7_0_5_6 0) vsource dc=0 mag=0
RI7_0_5_6 (vs7_0_5_6 vi7_0_5_6) resistor r=50
X0_5_6 (vdd0_5_6 0 s2_0_5_6 s1_0_5_6 s0_0_5_6 vi7_0_5_6 vi6_0_5_6 vi5_0_5_6 vi4_0_5_6 vi3_0_5_6 vi2_0_5_6 vi1_0_5_6 vi0_0_5_6 vo0_5_6) input_mux_8to1
CL0_5_6 (vo0_5_6 0) capacitor c=1p
save vo0_5_6 VDD0_5_6:p
VDD0_5_7 (vdsrc0_5_7 0) vsource dc=1.8
RVD0_5_7 (vdsrc0_5_7 vdd0_5_7) resistor r=50
VS0_0_5_7 (ss0_0_5_7 0) vsource dc=1.8
RS0_0_5_7 (ss0_0_5_7 s0_0_5_7) resistor r=50
VS1_0_5_7 (ss1_0_5_7 0) vsource dc=0
RS1_0_5_7 (ss1_0_5_7 s1_0_5_7) resistor r=50
VS2_0_5_7 (ss2_0_5_7 0) vsource dc=1.8
RS2_0_5_7 (ss2_0_5_7 s2_0_5_7) resistor r=50
VI0_0_5_7 (vs0_0_5_7 0) vsource dc=0 mag=0
RI0_0_5_7 (vs0_0_5_7 vi0_0_5_7) resistor r=50
VI1_0_5_7 (vs1_0_5_7 0) vsource dc=0 mag=0
RI1_0_5_7 (vs1_0_5_7 vi1_0_5_7) resistor r=50
VI2_0_5_7 (vs2_0_5_7 0) vsource dc=0 mag=0
RI2_0_5_7 (vs2_0_5_7 vi2_0_5_7) resistor r=50
VI3_0_5_7 (vs3_0_5_7 0) vsource dc=0 mag=0
RI3_0_5_7 (vs3_0_5_7 vi3_0_5_7) resistor r=50
VI4_0_5_7 (vs4_0_5_7 0) vsource dc=0 mag=0
RI4_0_5_7 (vs4_0_5_7 vi4_0_5_7) resistor r=50
VI5_0_5_7 (vs5_0_5_7 0) vsource dc=0 mag=0
RI5_0_5_7 (vs5_0_5_7 vi5_0_5_7) resistor r=50
VI6_0_5_7 (vs6_0_5_7 0) vsource dc=0 mag=0
RI6_0_5_7 (vs6_0_5_7 vi6_0_5_7) resistor r=50
VI7_0_5_7 (vs7_0_5_7 0) vsource dc=0 mag=1
RI7_0_5_7 (vs7_0_5_7 vi7_0_5_7) resistor r=50
X0_5_7 (vdd0_5_7 0 s2_0_5_7 s1_0_5_7 s0_0_5_7 vi7_0_5_7 vi6_0_5_7 vi5_0_5_7 vi4_0_5_7 vi3_0_5_7 vi2_0_5_7 vi1_0_5_7 vi0_0_5_7 vo0_5_7) input_mux_8to1
CL0_5_7 (vo0_5_7 0) capacitor c=1p
save vo0_5_7 VDD0_5_7:p
VDD0_6_0 (vdsrc0_6_0 0) vsource dc=1.8
RVD0_6_0 (vdsrc0_6_0 vdd0_6_0) resistor r=50
VS0_0_6_0 (ss0_0_6_0 0) vsource dc=0
RS0_0_6_0 (ss0_0_6_0 s0_0_6_0) resistor r=50
VS1_0_6_0 (ss1_0_6_0 0) vsource dc=1.8
RS1_0_6_0 (ss1_0_6_0 s1_0_6_0) resistor r=50
VS2_0_6_0 (ss2_0_6_0 0) vsource dc=1.8
RS2_0_6_0 (ss2_0_6_0 s2_0_6_0) resistor r=50
VI0_0_6_0 (vs0_0_6_0 0) vsource dc=0 mag=1
RI0_0_6_0 (vs0_0_6_0 vi0_0_6_0) resistor r=50
VI1_0_6_0 (vs1_0_6_0 0) vsource dc=0 mag=0
RI1_0_6_0 (vs1_0_6_0 vi1_0_6_0) resistor r=50
VI2_0_6_0 (vs2_0_6_0 0) vsource dc=0 mag=0
RI2_0_6_0 (vs2_0_6_0 vi2_0_6_0) resistor r=50
VI3_0_6_0 (vs3_0_6_0 0) vsource dc=0 mag=0
RI3_0_6_0 (vs3_0_6_0 vi3_0_6_0) resistor r=50
VI4_0_6_0 (vs4_0_6_0 0) vsource dc=0 mag=0
RI4_0_6_0 (vs4_0_6_0 vi4_0_6_0) resistor r=50
VI5_0_6_0 (vs5_0_6_0 0) vsource dc=0 mag=0
RI5_0_6_0 (vs5_0_6_0 vi5_0_6_0) resistor r=50
VI6_0_6_0 (vs6_0_6_0 0) vsource dc=0 mag=0
RI6_0_6_0 (vs6_0_6_0 vi6_0_6_0) resistor r=50
VI7_0_6_0 (vs7_0_6_0 0) vsource dc=0 mag=0
RI7_0_6_0 (vs7_0_6_0 vi7_0_6_0) resistor r=50
X0_6_0 (vdd0_6_0 0 s2_0_6_0 s1_0_6_0 s0_0_6_0 vi7_0_6_0 vi6_0_6_0 vi5_0_6_0 vi4_0_6_0 vi3_0_6_0 vi2_0_6_0 vi1_0_6_0 vi0_0_6_0 vo0_6_0) input_mux_8to1
CL0_6_0 (vo0_6_0 0) capacitor c=1p
save vo0_6_0 VDD0_6_0:p
VDD0_6_1 (vdsrc0_6_1 0) vsource dc=1.8
RVD0_6_1 (vdsrc0_6_1 vdd0_6_1) resistor r=50
VS0_0_6_1 (ss0_0_6_1 0) vsource dc=0
RS0_0_6_1 (ss0_0_6_1 s0_0_6_1) resistor r=50
VS1_0_6_1 (ss1_0_6_1 0) vsource dc=1.8
RS1_0_6_1 (ss1_0_6_1 s1_0_6_1) resistor r=50
VS2_0_6_1 (ss2_0_6_1 0) vsource dc=1.8
RS2_0_6_1 (ss2_0_6_1 s2_0_6_1) resistor r=50
VI0_0_6_1 (vs0_0_6_1 0) vsource dc=0 mag=0
RI0_0_6_1 (vs0_0_6_1 vi0_0_6_1) resistor r=50
VI1_0_6_1 (vs1_0_6_1 0) vsource dc=0 mag=1
RI1_0_6_1 (vs1_0_6_1 vi1_0_6_1) resistor r=50
VI2_0_6_1 (vs2_0_6_1 0) vsource dc=0 mag=0
RI2_0_6_1 (vs2_0_6_1 vi2_0_6_1) resistor r=50
VI3_0_6_1 (vs3_0_6_1 0) vsource dc=0 mag=0
RI3_0_6_1 (vs3_0_6_1 vi3_0_6_1) resistor r=50
VI4_0_6_1 (vs4_0_6_1 0) vsource dc=0 mag=0
RI4_0_6_1 (vs4_0_6_1 vi4_0_6_1) resistor r=50
VI5_0_6_1 (vs5_0_6_1 0) vsource dc=0 mag=0
RI5_0_6_1 (vs5_0_6_1 vi5_0_6_1) resistor r=50
VI6_0_6_1 (vs6_0_6_1 0) vsource dc=0 mag=0
RI6_0_6_1 (vs6_0_6_1 vi6_0_6_1) resistor r=50
VI7_0_6_1 (vs7_0_6_1 0) vsource dc=0 mag=0
RI7_0_6_1 (vs7_0_6_1 vi7_0_6_1) resistor r=50
X0_6_1 (vdd0_6_1 0 s2_0_6_1 s1_0_6_1 s0_0_6_1 vi7_0_6_1 vi6_0_6_1 vi5_0_6_1 vi4_0_6_1 vi3_0_6_1 vi2_0_6_1 vi1_0_6_1 vi0_0_6_1 vo0_6_1) input_mux_8to1
CL0_6_1 (vo0_6_1 0) capacitor c=1p
save vo0_6_1 VDD0_6_1:p
VDD0_6_2 (vdsrc0_6_2 0) vsource dc=1.8
RVD0_6_2 (vdsrc0_6_2 vdd0_6_2) resistor r=50
VS0_0_6_2 (ss0_0_6_2 0) vsource dc=0
RS0_0_6_2 (ss0_0_6_2 s0_0_6_2) resistor r=50
VS1_0_6_2 (ss1_0_6_2 0) vsource dc=1.8
RS1_0_6_2 (ss1_0_6_2 s1_0_6_2) resistor r=50
VS2_0_6_2 (ss2_0_6_2 0) vsource dc=1.8
RS2_0_6_2 (ss2_0_6_2 s2_0_6_2) resistor r=50
VI0_0_6_2 (vs0_0_6_2 0) vsource dc=0 mag=0
RI0_0_6_2 (vs0_0_6_2 vi0_0_6_2) resistor r=50
VI1_0_6_2 (vs1_0_6_2 0) vsource dc=0 mag=0
RI1_0_6_2 (vs1_0_6_2 vi1_0_6_2) resistor r=50
VI2_0_6_2 (vs2_0_6_2 0) vsource dc=0 mag=1
RI2_0_6_2 (vs2_0_6_2 vi2_0_6_2) resistor r=50
VI3_0_6_2 (vs3_0_6_2 0) vsource dc=0 mag=0
RI3_0_6_2 (vs3_0_6_2 vi3_0_6_2) resistor r=50
VI4_0_6_2 (vs4_0_6_2 0) vsource dc=0 mag=0
RI4_0_6_2 (vs4_0_6_2 vi4_0_6_2) resistor r=50
VI5_0_6_2 (vs5_0_6_2 0) vsource dc=0 mag=0
RI5_0_6_2 (vs5_0_6_2 vi5_0_6_2) resistor r=50
VI6_0_6_2 (vs6_0_6_2 0) vsource dc=0 mag=0
RI6_0_6_2 (vs6_0_6_2 vi6_0_6_2) resistor r=50
VI7_0_6_2 (vs7_0_6_2 0) vsource dc=0 mag=0
RI7_0_6_2 (vs7_0_6_2 vi7_0_6_2) resistor r=50
X0_6_2 (vdd0_6_2 0 s2_0_6_2 s1_0_6_2 s0_0_6_2 vi7_0_6_2 vi6_0_6_2 vi5_0_6_2 vi4_0_6_2 vi3_0_6_2 vi2_0_6_2 vi1_0_6_2 vi0_0_6_2 vo0_6_2) input_mux_8to1
CL0_6_2 (vo0_6_2 0) capacitor c=1p
save vo0_6_2 VDD0_6_2:p
VDD0_6_3 (vdsrc0_6_3 0) vsource dc=1.8
RVD0_6_3 (vdsrc0_6_3 vdd0_6_3) resistor r=50
VS0_0_6_3 (ss0_0_6_3 0) vsource dc=0
RS0_0_6_3 (ss0_0_6_3 s0_0_6_3) resistor r=50
VS1_0_6_3 (ss1_0_6_3 0) vsource dc=1.8
RS1_0_6_3 (ss1_0_6_3 s1_0_6_3) resistor r=50
VS2_0_6_3 (ss2_0_6_3 0) vsource dc=1.8
RS2_0_6_3 (ss2_0_6_3 s2_0_6_3) resistor r=50
VI0_0_6_3 (vs0_0_6_3 0) vsource dc=0 mag=0
RI0_0_6_3 (vs0_0_6_3 vi0_0_6_3) resistor r=50
VI1_0_6_3 (vs1_0_6_3 0) vsource dc=0 mag=0
RI1_0_6_3 (vs1_0_6_3 vi1_0_6_3) resistor r=50
VI2_0_6_3 (vs2_0_6_3 0) vsource dc=0 mag=0
RI2_0_6_3 (vs2_0_6_3 vi2_0_6_3) resistor r=50
VI3_0_6_3 (vs3_0_6_3 0) vsource dc=0 mag=1
RI3_0_6_3 (vs3_0_6_3 vi3_0_6_3) resistor r=50
VI4_0_6_3 (vs4_0_6_3 0) vsource dc=0 mag=0
RI4_0_6_3 (vs4_0_6_3 vi4_0_6_3) resistor r=50
VI5_0_6_3 (vs5_0_6_3 0) vsource dc=0 mag=0
RI5_0_6_3 (vs5_0_6_3 vi5_0_6_3) resistor r=50
VI6_0_6_3 (vs6_0_6_3 0) vsource dc=0 mag=0
RI6_0_6_3 (vs6_0_6_3 vi6_0_6_3) resistor r=50
VI7_0_6_3 (vs7_0_6_3 0) vsource dc=0 mag=0
RI7_0_6_3 (vs7_0_6_3 vi7_0_6_3) resistor r=50
X0_6_3 (vdd0_6_3 0 s2_0_6_3 s1_0_6_3 s0_0_6_3 vi7_0_6_3 vi6_0_6_3 vi5_0_6_3 vi4_0_6_3 vi3_0_6_3 vi2_0_6_3 vi1_0_6_3 vi0_0_6_3 vo0_6_3) input_mux_8to1
CL0_6_3 (vo0_6_3 0) capacitor c=1p
save vo0_6_3 VDD0_6_3:p
VDD0_6_4 (vdsrc0_6_4 0) vsource dc=1.8
RVD0_6_4 (vdsrc0_6_4 vdd0_6_4) resistor r=50
VS0_0_6_4 (ss0_0_6_4 0) vsource dc=0
RS0_0_6_4 (ss0_0_6_4 s0_0_6_4) resistor r=50
VS1_0_6_4 (ss1_0_6_4 0) vsource dc=1.8
RS1_0_6_4 (ss1_0_6_4 s1_0_6_4) resistor r=50
VS2_0_6_4 (ss2_0_6_4 0) vsource dc=1.8
RS2_0_6_4 (ss2_0_6_4 s2_0_6_4) resistor r=50
VI0_0_6_4 (vs0_0_6_4 0) vsource dc=0 mag=0
RI0_0_6_4 (vs0_0_6_4 vi0_0_6_4) resistor r=50
VI1_0_6_4 (vs1_0_6_4 0) vsource dc=0 mag=0
RI1_0_6_4 (vs1_0_6_4 vi1_0_6_4) resistor r=50
VI2_0_6_4 (vs2_0_6_4 0) vsource dc=0 mag=0
RI2_0_6_4 (vs2_0_6_4 vi2_0_6_4) resistor r=50
VI3_0_6_4 (vs3_0_6_4 0) vsource dc=0 mag=0
RI3_0_6_4 (vs3_0_6_4 vi3_0_6_4) resistor r=50
VI4_0_6_4 (vs4_0_6_4 0) vsource dc=0 mag=1
RI4_0_6_4 (vs4_0_6_4 vi4_0_6_4) resistor r=50
VI5_0_6_4 (vs5_0_6_4 0) vsource dc=0 mag=0
RI5_0_6_4 (vs5_0_6_4 vi5_0_6_4) resistor r=50
VI6_0_6_4 (vs6_0_6_4 0) vsource dc=0 mag=0
RI6_0_6_4 (vs6_0_6_4 vi6_0_6_4) resistor r=50
VI7_0_6_4 (vs7_0_6_4 0) vsource dc=0 mag=0
RI7_0_6_4 (vs7_0_6_4 vi7_0_6_4) resistor r=50
X0_6_4 (vdd0_6_4 0 s2_0_6_4 s1_0_6_4 s0_0_6_4 vi7_0_6_4 vi6_0_6_4 vi5_0_6_4 vi4_0_6_4 vi3_0_6_4 vi2_0_6_4 vi1_0_6_4 vi0_0_6_4 vo0_6_4) input_mux_8to1
CL0_6_4 (vo0_6_4 0) capacitor c=1p
save vo0_6_4 VDD0_6_4:p
VDD0_6_5 (vdsrc0_6_5 0) vsource dc=1.8
RVD0_6_5 (vdsrc0_6_5 vdd0_6_5) resistor r=50
VS0_0_6_5 (ss0_0_6_5 0) vsource dc=0
RS0_0_6_5 (ss0_0_6_5 s0_0_6_5) resistor r=50
VS1_0_6_5 (ss1_0_6_5 0) vsource dc=1.8
RS1_0_6_5 (ss1_0_6_5 s1_0_6_5) resistor r=50
VS2_0_6_5 (ss2_0_6_5 0) vsource dc=1.8
RS2_0_6_5 (ss2_0_6_5 s2_0_6_5) resistor r=50
VI0_0_6_5 (vs0_0_6_5 0) vsource dc=0 mag=0
RI0_0_6_5 (vs0_0_6_5 vi0_0_6_5) resistor r=50
VI1_0_6_5 (vs1_0_6_5 0) vsource dc=0 mag=0
RI1_0_6_5 (vs1_0_6_5 vi1_0_6_5) resistor r=50
VI2_0_6_5 (vs2_0_6_5 0) vsource dc=0 mag=0
RI2_0_6_5 (vs2_0_6_5 vi2_0_6_5) resistor r=50
VI3_0_6_5 (vs3_0_6_5 0) vsource dc=0 mag=0
RI3_0_6_5 (vs3_0_6_5 vi3_0_6_5) resistor r=50
VI4_0_6_5 (vs4_0_6_5 0) vsource dc=0 mag=0
RI4_0_6_5 (vs4_0_6_5 vi4_0_6_5) resistor r=50
VI5_0_6_5 (vs5_0_6_5 0) vsource dc=0 mag=1
RI5_0_6_5 (vs5_0_6_5 vi5_0_6_5) resistor r=50
VI6_0_6_5 (vs6_0_6_5 0) vsource dc=0 mag=0
RI6_0_6_5 (vs6_0_6_5 vi6_0_6_5) resistor r=50
VI7_0_6_5 (vs7_0_6_5 0) vsource dc=0 mag=0
RI7_0_6_5 (vs7_0_6_5 vi7_0_6_5) resistor r=50
X0_6_5 (vdd0_6_5 0 s2_0_6_5 s1_0_6_5 s0_0_6_5 vi7_0_6_5 vi6_0_6_5 vi5_0_6_5 vi4_0_6_5 vi3_0_6_5 vi2_0_6_5 vi1_0_6_5 vi0_0_6_5 vo0_6_5) input_mux_8to1
CL0_6_5 (vo0_6_5 0) capacitor c=1p
save vo0_6_5 VDD0_6_5:p
VDD0_6_6 (vdsrc0_6_6 0) vsource dc=1.8
RVD0_6_6 (vdsrc0_6_6 vdd0_6_6) resistor r=50
VS0_0_6_6 (ss0_0_6_6 0) vsource dc=0
RS0_0_6_6 (ss0_0_6_6 s0_0_6_6) resistor r=50
VS1_0_6_6 (ss1_0_6_6 0) vsource dc=1.8
RS1_0_6_6 (ss1_0_6_6 s1_0_6_6) resistor r=50
VS2_0_6_6 (ss2_0_6_6 0) vsource dc=1.8
RS2_0_6_6 (ss2_0_6_6 s2_0_6_6) resistor r=50
VI0_0_6_6 (vs0_0_6_6 0) vsource dc=0 mag=0
RI0_0_6_6 (vs0_0_6_6 vi0_0_6_6) resistor r=50
VI1_0_6_6 (vs1_0_6_6 0) vsource dc=0 mag=0
RI1_0_6_6 (vs1_0_6_6 vi1_0_6_6) resistor r=50
VI2_0_6_6 (vs2_0_6_6 0) vsource dc=0 mag=0
RI2_0_6_6 (vs2_0_6_6 vi2_0_6_6) resistor r=50
VI3_0_6_6 (vs3_0_6_6 0) vsource dc=0 mag=0
RI3_0_6_6 (vs3_0_6_6 vi3_0_6_6) resistor r=50
VI4_0_6_6 (vs4_0_6_6 0) vsource dc=0 mag=0
RI4_0_6_6 (vs4_0_6_6 vi4_0_6_6) resistor r=50
VI5_0_6_6 (vs5_0_6_6 0) vsource dc=0 mag=0
RI5_0_6_6 (vs5_0_6_6 vi5_0_6_6) resistor r=50
VI6_0_6_6 (vs6_0_6_6 0) vsource dc=0 mag=1
RI6_0_6_6 (vs6_0_6_6 vi6_0_6_6) resistor r=50
VI7_0_6_6 (vs7_0_6_6 0) vsource dc=0 mag=0
RI7_0_6_6 (vs7_0_6_6 vi7_0_6_6) resistor r=50
X0_6_6 (vdd0_6_6 0 s2_0_6_6 s1_0_6_6 s0_0_6_6 vi7_0_6_6 vi6_0_6_6 vi5_0_6_6 vi4_0_6_6 vi3_0_6_6 vi2_0_6_6 vi1_0_6_6 vi0_0_6_6 vo0_6_6) input_mux_8to1
CL0_6_6 (vo0_6_6 0) capacitor c=1p
save vo0_6_6 VDD0_6_6:p
VDD0_6_7 (vdsrc0_6_7 0) vsource dc=1.8
RVD0_6_7 (vdsrc0_6_7 vdd0_6_7) resistor r=50
VS0_0_6_7 (ss0_0_6_7 0) vsource dc=0
RS0_0_6_7 (ss0_0_6_7 s0_0_6_7) resistor r=50
VS1_0_6_7 (ss1_0_6_7 0) vsource dc=1.8
RS1_0_6_7 (ss1_0_6_7 s1_0_6_7) resistor r=50
VS2_0_6_7 (ss2_0_6_7 0) vsource dc=1.8
RS2_0_6_7 (ss2_0_6_7 s2_0_6_7) resistor r=50
VI0_0_6_7 (vs0_0_6_7 0) vsource dc=0 mag=0
RI0_0_6_7 (vs0_0_6_7 vi0_0_6_7) resistor r=50
VI1_0_6_7 (vs1_0_6_7 0) vsource dc=0 mag=0
RI1_0_6_7 (vs1_0_6_7 vi1_0_6_7) resistor r=50
VI2_0_6_7 (vs2_0_6_7 0) vsource dc=0 mag=0
RI2_0_6_7 (vs2_0_6_7 vi2_0_6_7) resistor r=50
VI3_0_6_7 (vs3_0_6_7 0) vsource dc=0 mag=0
RI3_0_6_7 (vs3_0_6_7 vi3_0_6_7) resistor r=50
VI4_0_6_7 (vs4_0_6_7 0) vsource dc=0 mag=0
RI4_0_6_7 (vs4_0_6_7 vi4_0_6_7) resistor r=50
VI5_0_6_7 (vs5_0_6_7 0) vsource dc=0 mag=0
RI5_0_6_7 (vs5_0_6_7 vi5_0_6_7) resistor r=50
VI6_0_6_7 (vs6_0_6_7 0) vsource dc=0 mag=0
RI6_0_6_7 (vs6_0_6_7 vi6_0_6_7) resistor r=50
VI7_0_6_7 (vs7_0_6_7 0) vsource dc=0 mag=1
RI7_0_6_7 (vs7_0_6_7 vi7_0_6_7) resistor r=50
X0_6_7 (vdd0_6_7 0 s2_0_6_7 s1_0_6_7 s0_0_6_7 vi7_0_6_7 vi6_0_6_7 vi5_0_6_7 vi4_0_6_7 vi3_0_6_7 vi2_0_6_7 vi1_0_6_7 vi0_0_6_7 vo0_6_7) input_mux_8to1
CL0_6_7 (vo0_6_7 0) capacitor c=1p
save vo0_6_7 VDD0_6_7:p
VDD0_7_0 (vdsrc0_7_0 0) vsource dc=1.8
RVD0_7_0 (vdsrc0_7_0 vdd0_7_0) resistor r=50
VS0_0_7_0 (ss0_0_7_0 0) vsource dc=1.8
RS0_0_7_0 (ss0_0_7_0 s0_0_7_0) resistor r=50
VS1_0_7_0 (ss1_0_7_0 0) vsource dc=1.8
RS1_0_7_0 (ss1_0_7_0 s1_0_7_0) resistor r=50
VS2_0_7_0 (ss2_0_7_0 0) vsource dc=1.8
RS2_0_7_0 (ss2_0_7_0 s2_0_7_0) resistor r=50
VI0_0_7_0 (vs0_0_7_0 0) vsource dc=0 mag=1
RI0_0_7_0 (vs0_0_7_0 vi0_0_7_0) resistor r=50
VI1_0_7_0 (vs1_0_7_0 0) vsource dc=0 mag=0
RI1_0_7_0 (vs1_0_7_0 vi1_0_7_0) resistor r=50
VI2_0_7_0 (vs2_0_7_0 0) vsource dc=0 mag=0
RI2_0_7_0 (vs2_0_7_0 vi2_0_7_0) resistor r=50
VI3_0_7_0 (vs3_0_7_0 0) vsource dc=0 mag=0
RI3_0_7_0 (vs3_0_7_0 vi3_0_7_0) resistor r=50
VI4_0_7_0 (vs4_0_7_0 0) vsource dc=0 mag=0
RI4_0_7_0 (vs4_0_7_0 vi4_0_7_0) resistor r=50
VI5_0_7_0 (vs5_0_7_0 0) vsource dc=0 mag=0
RI5_0_7_0 (vs5_0_7_0 vi5_0_7_0) resistor r=50
VI6_0_7_0 (vs6_0_7_0 0) vsource dc=0 mag=0
RI6_0_7_0 (vs6_0_7_0 vi6_0_7_0) resistor r=50
VI7_0_7_0 (vs7_0_7_0 0) vsource dc=0 mag=0
RI7_0_7_0 (vs7_0_7_0 vi7_0_7_0) resistor r=50
X0_7_0 (vdd0_7_0 0 s2_0_7_0 s1_0_7_0 s0_0_7_0 vi7_0_7_0 vi6_0_7_0 vi5_0_7_0 vi4_0_7_0 vi3_0_7_0 vi2_0_7_0 vi1_0_7_0 vi0_0_7_0 vo0_7_0) input_mux_8to1
CL0_7_0 (vo0_7_0 0) capacitor c=1p
save vo0_7_0 VDD0_7_0:p
VDD0_7_1 (vdsrc0_7_1 0) vsource dc=1.8
RVD0_7_1 (vdsrc0_7_1 vdd0_7_1) resistor r=50
VS0_0_7_1 (ss0_0_7_1 0) vsource dc=1.8
RS0_0_7_1 (ss0_0_7_1 s0_0_7_1) resistor r=50
VS1_0_7_1 (ss1_0_7_1 0) vsource dc=1.8
RS1_0_7_1 (ss1_0_7_1 s1_0_7_1) resistor r=50
VS2_0_7_1 (ss2_0_7_1 0) vsource dc=1.8
RS2_0_7_1 (ss2_0_7_1 s2_0_7_1) resistor r=50
VI0_0_7_1 (vs0_0_7_1 0) vsource dc=0 mag=0
RI0_0_7_1 (vs0_0_7_1 vi0_0_7_1) resistor r=50
VI1_0_7_1 (vs1_0_7_1 0) vsource dc=0 mag=1
RI1_0_7_1 (vs1_0_7_1 vi1_0_7_1) resistor r=50
VI2_0_7_1 (vs2_0_7_1 0) vsource dc=0 mag=0
RI2_0_7_1 (vs2_0_7_1 vi2_0_7_1) resistor r=50
VI3_0_7_1 (vs3_0_7_1 0) vsource dc=0 mag=0
RI3_0_7_1 (vs3_0_7_1 vi3_0_7_1) resistor r=50
VI4_0_7_1 (vs4_0_7_1 0) vsource dc=0 mag=0
RI4_0_7_1 (vs4_0_7_1 vi4_0_7_1) resistor r=50
VI5_0_7_1 (vs5_0_7_1 0) vsource dc=0 mag=0
RI5_0_7_1 (vs5_0_7_1 vi5_0_7_1) resistor r=50
VI6_0_7_1 (vs6_0_7_1 0) vsource dc=0 mag=0
RI6_0_7_1 (vs6_0_7_1 vi6_0_7_1) resistor r=50
VI7_0_7_1 (vs7_0_7_1 0) vsource dc=0 mag=0
RI7_0_7_1 (vs7_0_7_1 vi7_0_7_1) resistor r=50
X0_7_1 (vdd0_7_1 0 s2_0_7_1 s1_0_7_1 s0_0_7_1 vi7_0_7_1 vi6_0_7_1 vi5_0_7_1 vi4_0_7_1 vi3_0_7_1 vi2_0_7_1 vi1_0_7_1 vi0_0_7_1 vo0_7_1) input_mux_8to1
CL0_7_1 (vo0_7_1 0) capacitor c=1p
save vo0_7_1 VDD0_7_1:p
VDD0_7_2 (vdsrc0_7_2 0) vsource dc=1.8
RVD0_7_2 (vdsrc0_7_2 vdd0_7_2) resistor r=50
VS0_0_7_2 (ss0_0_7_2 0) vsource dc=1.8
RS0_0_7_2 (ss0_0_7_2 s0_0_7_2) resistor r=50
VS1_0_7_2 (ss1_0_7_2 0) vsource dc=1.8
RS1_0_7_2 (ss1_0_7_2 s1_0_7_2) resistor r=50
VS2_0_7_2 (ss2_0_7_2 0) vsource dc=1.8
RS2_0_7_2 (ss2_0_7_2 s2_0_7_2) resistor r=50
VI0_0_7_2 (vs0_0_7_2 0) vsource dc=0 mag=0
RI0_0_7_2 (vs0_0_7_2 vi0_0_7_2) resistor r=50
VI1_0_7_2 (vs1_0_7_2 0) vsource dc=0 mag=0
RI1_0_7_2 (vs1_0_7_2 vi1_0_7_2) resistor r=50
VI2_0_7_2 (vs2_0_7_2 0) vsource dc=0 mag=1
RI2_0_7_2 (vs2_0_7_2 vi2_0_7_2) resistor r=50
VI3_0_7_2 (vs3_0_7_2 0) vsource dc=0 mag=0
RI3_0_7_2 (vs3_0_7_2 vi3_0_7_2) resistor r=50
VI4_0_7_2 (vs4_0_7_2 0) vsource dc=0 mag=0
RI4_0_7_2 (vs4_0_7_2 vi4_0_7_2) resistor r=50
VI5_0_7_2 (vs5_0_7_2 0) vsource dc=0 mag=0
RI5_0_7_2 (vs5_0_7_2 vi5_0_7_2) resistor r=50
VI6_0_7_2 (vs6_0_7_2 0) vsource dc=0 mag=0
RI6_0_7_2 (vs6_0_7_2 vi6_0_7_2) resistor r=50
VI7_0_7_2 (vs7_0_7_2 0) vsource dc=0 mag=0
RI7_0_7_2 (vs7_0_7_2 vi7_0_7_2) resistor r=50
X0_7_2 (vdd0_7_2 0 s2_0_7_2 s1_0_7_2 s0_0_7_2 vi7_0_7_2 vi6_0_7_2 vi5_0_7_2 vi4_0_7_2 vi3_0_7_2 vi2_0_7_2 vi1_0_7_2 vi0_0_7_2 vo0_7_2) input_mux_8to1
CL0_7_2 (vo0_7_2 0) capacitor c=1p
save vo0_7_2 VDD0_7_2:p
VDD0_7_3 (vdsrc0_7_3 0) vsource dc=1.8
RVD0_7_3 (vdsrc0_7_3 vdd0_7_3) resistor r=50
VS0_0_7_3 (ss0_0_7_3 0) vsource dc=1.8
RS0_0_7_3 (ss0_0_7_3 s0_0_7_3) resistor r=50
VS1_0_7_3 (ss1_0_7_3 0) vsource dc=1.8
RS1_0_7_3 (ss1_0_7_3 s1_0_7_3) resistor r=50
VS2_0_7_3 (ss2_0_7_3 0) vsource dc=1.8
RS2_0_7_3 (ss2_0_7_3 s2_0_7_3) resistor r=50
VI0_0_7_3 (vs0_0_7_3 0) vsource dc=0 mag=0
RI0_0_7_3 (vs0_0_7_3 vi0_0_7_3) resistor r=50
VI1_0_7_3 (vs1_0_7_3 0) vsource dc=0 mag=0
RI1_0_7_3 (vs1_0_7_3 vi1_0_7_3) resistor r=50
VI2_0_7_3 (vs2_0_7_3 0) vsource dc=0 mag=0
RI2_0_7_3 (vs2_0_7_3 vi2_0_7_3) resistor r=50
VI3_0_7_3 (vs3_0_7_3 0) vsource dc=0 mag=1
RI3_0_7_3 (vs3_0_7_3 vi3_0_7_3) resistor r=50
VI4_0_7_3 (vs4_0_7_3 0) vsource dc=0 mag=0
RI4_0_7_3 (vs4_0_7_3 vi4_0_7_3) resistor r=50
VI5_0_7_3 (vs5_0_7_3 0) vsource dc=0 mag=0
RI5_0_7_3 (vs5_0_7_3 vi5_0_7_3) resistor r=50
VI6_0_7_3 (vs6_0_7_3 0) vsource dc=0 mag=0
RI6_0_7_3 (vs6_0_7_3 vi6_0_7_3) resistor r=50
VI7_0_7_3 (vs7_0_7_3 0) vsource dc=0 mag=0
RI7_0_7_3 (vs7_0_7_3 vi7_0_7_3) resistor r=50
X0_7_3 (vdd0_7_3 0 s2_0_7_3 s1_0_7_3 s0_0_7_3 vi7_0_7_3 vi6_0_7_3 vi5_0_7_3 vi4_0_7_3 vi3_0_7_3 vi2_0_7_3 vi1_0_7_3 vi0_0_7_3 vo0_7_3) input_mux_8to1
CL0_7_3 (vo0_7_3 0) capacitor c=1p
save vo0_7_3 VDD0_7_3:p
VDD0_7_4 (vdsrc0_7_4 0) vsource dc=1.8
RVD0_7_4 (vdsrc0_7_4 vdd0_7_4) resistor r=50
VS0_0_7_4 (ss0_0_7_4 0) vsource dc=1.8
RS0_0_7_4 (ss0_0_7_4 s0_0_7_4) resistor r=50
VS1_0_7_4 (ss1_0_7_4 0) vsource dc=1.8
RS1_0_7_4 (ss1_0_7_4 s1_0_7_4) resistor r=50
VS2_0_7_4 (ss2_0_7_4 0) vsource dc=1.8
RS2_0_7_4 (ss2_0_7_4 s2_0_7_4) resistor r=50
VI0_0_7_4 (vs0_0_7_4 0) vsource dc=0 mag=0
RI0_0_7_4 (vs0_0_7_4 vi0_0_7_4) resistor r=50
VI1_0_7_4 (vs1_0_7_4 0) vsource dc=0 mag=0
RI1_0_7_4 (vs1_0_7_4 vi1_0_7_4) resistor r=50
VI2_0_7_4 (vs2_0_7_4 0) vsource dc=0 mag=0
RI2_0_7_4 (vs2_0_7_4 vi2_0_7_4) resistor r=50
VI3_0_7_4 (vs3_0_7_4 0) vsource dc=0 mag=0
RI3_0_7_4 (vs3_0_7_4 vi3_0_7_4) resistor r=50
VI4_0_7_4 (vs4_0_7_4 0) vsource dc=0 mag=1
RI4_0_7_4 (vs4_0_7_4 vi4_0_7_4) resistor r=50
VI5_0_7_4 (vs5_0_7_4 0) vsource dc=0 mag=0
RI5_0_7_4 (vs5_0_7_4 vi5_0_7_4) resistor r=50
VI6_0_7_4 (vs6_0_7_4 0) vsource dc=0 mag=0
RI6_0_7_4 (vs6_0_7_4 vi6_0_7_4) resistor r=50
VI7_0_7_4 (vs7_0_7_4 0) vsource dc=0 mag=0
RI7_0_7_4 (vs7_0_7_4 vi7_0_7_4) resistor r=50
X0_7_4 (vdd0_7_4 0 s2_0_7_4 s1_0_7_4 s0_0_7_4 vi7_0_7_4 vi6_0_7_4 vi5_0_7_4 vi4_0_7_4 vi3_0_7_4 vi2_0_7_4 vi1_0_7_4 vi0_0_7_4 vo0_7_4) input_mux_8to1
CL0_7_4 (vo0_7_4 0) capacitor c=1p
save vo0_7_4 VDD0_7_4:p
VDD0_7_5 (vdsrc0_7_5 0) vsource dc=1.8
RVD0_7_5 (vdsrc0_7_5 vdd0_7_5) resistor r=50
VS0_0_7_5 (ss0_0_7_5 0) vsource dc=1.8
RS0_0_7_5 (ss0_0_7_5 s0_0_7_5) resistor r=50
VS1_0_7_5 (ss1_0_7_5 0) vsource dc=1.8
RS1_0_7_5 (ss1_0_7_5 s1_0_7_5) resistor r=50
VS2_0_7_5 (ss2_0_7_5 0) vsource dc=1.8
RS2_0_7_5 (ss2_0_7_5 s2_0_7_5) resistor r=50
VI0_0_7_5 (vs0_0_7_5 0) vsource dc=0 mag=0
RI0_0_7_5 (vs0_0_7_5 vi0_0_7_5) resistor r=50
VI1_0_7_5 (vs1_0_7_5 0) vsource dc=0 mag=0
RI1_0_7_5 (vs1_0_7_5 vi1_0_7_5) resistor r=50
VI2_0_7_5 (vs2_0_7_5 0) vsource dc=0 mag=0
RI2_0_7_5 (vs2_0_7_5 vi2_0_7_5) resistor r=50
VI3_0_7_5 (vs3_0_7_5 0) vsource dc=0 mag=0
RI3_0_7_5 (vs3_0_7_5 vi3_0_7_5) resistor r=50
VI4_0_7_5 (vs4_0_7_5 0) vsource dc=0 mag=0
RI4_0_7_5 (vs4_0_7_5 vi4_0_7_5) resistor r=50
VI5_0_7_5 (vs5_0_7_5 0) vsource dc=0 mag=1
RI5_0_7_5 (vs5_0_7_5 vi5_0_7_5) resistor r=50
VI6_0_7_5 (vs6_0_7_5 0) vsource dc=0 mag=0
RI6_0_7_5 (vs6_0_7_5 vi6_0_7_5) resistor r=50
VI7_0_7_5 (vs7_0_7_5 0) vsource dc=0 mag=0
RI7_0_7_5 (vs7_0_7_5 vi7_0_7_5) resistor r=50
X0_7_5 (vdd0_7_5 0 s2_0_7_5 s1_0_7_5 s0_0_7_5 vi7_0_7_5 vi6_0_7_5 vi5_0_7_5 vi4_0_7_5 vi3_0_7_5 vi2_0_7_5 vi1_0_7_5 vi0_0_7_5 vo0_7_5) input_mux_8to1
CL0_7_5 (vo0_7_5 0) capacitor c=1p
save vo0_7_5 VDD0_7_5:p
VDD0_7_6 (vdsrc0_7_6 0) vsource dc=1.8
RVD0_7_6 (vdsrc0_7_6 vdd0_7_6) resistor r=50
VS0_0_7_6 (ss0_0_7_6 0) vsource dc=1.8
RS0_0_7_6 (ss0_0_7_6 s0_0_7_6) resistor r=50
VS1_0_7_6 (ss1_0_7_6 0) vsource dc=1.8
RS1_0_7_6 (ss1_0_7_6 s1_0_7_6) resistor r=50
VS2_0_7_6 (ss2_0_7_6 0) vsource dc=1.8
RS2_0_7_6 (ss2_0_7_6 s2_0_7_6) resistor r=50
VI0_0_7_6 (vs0_0_7_6 0) vsource dc=0 mag=0
RI0_0_7_6 (vs0_0_7_6 vi0_0_7_6) resistor r=50
VI1_0_7_6 (vs1_0_7_6 0) vsource dc=0 mag=0
RI1_0_7_6 (vs1_0_7_6 vi1_0_7_6) resistor r=50
VI2_0_7_6 (vs2_0_7_6 0) vsource dc=0 mag=0
RI2_0_7_6 (vs2_0_7_6 vi2_0_7_6) resistor r=50
VI3_0_7_6 (vs3_0_7_6 0) vsource dc=0 mag=0
RI3_0_7_6 (vs3_0_7_6 vi3_0_7_6) resistor r=50
VI4_0_7_6 (vs4_0_7_6 0) vsource dc=0 mag=0
RI4_0_7_6 (vs4_0_7_6 vi4_0_7_6) resistor r=50
VI5_0_7_6 (vs5_0_7_6 0) vsource dc=0 mag=0
RI5_0_7_6 (vs5_0_7_6 vi5_0_7_6) resistor r=50
VI6_0_7_6 (vs6_0_7_6 0) vsource dc=0 mag=1
RI6_0_7_6 (vs6_0_7_6 vi6_0_7_6) resistor r=50
VI7_0_7_6 (vs7_0_7_6 0) vsource dc=0 mag=0
RI7_0_7_6 (vs7_0_7_6 vi7_0_7_6) resistor r=50
X0_7_6 (vdd0_7_6 0 s2_0_7_6 s1_0_7_6 s0_0_7_6 vi7_0_7_6 vi6_0_7_6 vi5_0_7_6 vi4_0_7_6 vi3_0_7_6 vi2_0_7_6 vi1_0_7_6 vi0_0_7_6 vo0_7_6) input_mux_8to1
CL0_7_6 (vo0_7_6 0) capacitor c=1p
save vo0_7_6 VDD0_7_6:p
VDD0_7_7 (vdsrc0_7_7 0) vsource dc=1.8
RVD0_7_7 (vdsrc0_7_7 vdd0_7_7) resistor r=50
VS0_0_7_7 (ss0_0_7_7 0) vsource dc=1.8
RS0_0_7_7 (ss0_0_7_7 s0_0_7_7) resistor r=50
VS1_0_7_7 (ss1_0_7_7 0) vsource dc=1.8
RS1_0_7_7 (ss1_0_7_7 s1_0_7_7) resistor r=50
VS2_0_7_7 (ss2_0_7_7 0) vsource dc=1.8
RS2_0_7_7 (ss2_0_7_7 s2_0_7_7) resistor r=50
VI0_0_7_7 (vs0_0_7_7 0) vsource dc=0 mag=0
RI0_0_7_7 (vs0_0_7_7 vi0_0_7_7) resistor r=50
VI1_0_7_7 (vs1_0_7_7 0) vsource dc=0 mag=0
RI1_0_7_7 (vs1_0_7_7 vi1_0_7_7) resistor r=50
VI2_0_7_7 (vs2_0_7_7 0) vsource dc=0 mag=0
RI2_0_7_7 (vs2_0_7_7 vi2_0_7_7) resistor r=50
VI3_0_7_7 (vs3_0_7_7 0) vsource dc=0 mag=0
RI3_0_7_7 (vs3_0_7_7 vi3_0_7_7) resistor r=50
VI4_0_7_7 (vs4_0_7_7 0) vsource dc=0 mag=0
RI4_0_7_7 (vs4_0_7_7 vi4_0_7_7) resistor r=50
VI5_0_7_7 (vs5_0_7_7 0) vsource dc=0 mag=0
RI5_0_7_7 (vs5_0_7_7 vi5_0_7_7) resistor r=50
VI6_0_7_7 (vs6_0_7_7 0) vsource dc=0 mag=0
RI6_0_7_7 (vs6_0_7_7 vi6_0_7_7) resistor r=50
VI7_0_7_7 (vs7_0_7_7 0) vsource dc=0 mag=1
RI7_0_7_7 (vs7_0_7_7 vi7_0_7_7) resistor r=50
X0_7_7 (vdd0_7_7 0 s2_0_7_7 s1_0_7_7 s0_0_7_7 vi7_0_7_7 vi6_0_7_7 vi5_0_7_7 vi4_0_7_7 vi3_0_7_7 vi2_0_7_7 vi1_0_7_7 vi0_0_7_7 vo0_7_7) input_mux_8to1
CL0_7_7 (vo0_7_7 0) capacitor c=1p
save vo0_7_7 VDD0_7_7:p
VDD1_0_0 (vdsrc1_0_0 0) vsource dc=1.8
RVD1_0_0 (vdsrc1_0_0 vdd1_0_0) resistor r=50
VS0_1_0_0 (ss0_1_0_0 0) vsource dc=0
RS0_1_0_0 (ss0_1_0_0 s0_1_0_0) resistor r=50
VS1_1_0_0 (ss1_1_0_0 0) vsource dc=0
RS1_1_0_0 (ss1_1_0_0 s1_1_0_0) resistor r=50
VS2_1_0_0 (ss2_1_0_0 0) vsource dc=0
RS2_1_0_0 (ss2_1_0_0 s2_1_0_0) resistor r=50
VI0_1_0_0 (vs0_1_0_0 0) vsource dc=0.9 mag=1
RI0_1_0_0 (vs0_1_0_0 vi0_1_0_0) resistor r=50
VI1_1_0_0 (vs1_1_0_0 0) vsource dc=0.9 mag=0
RI1_1_0_0 (vs1_1_0_0 vi1_1_0_0) resistor r=50
VI2_1_0_0 (vs2_1_0_0 0) vsource dc=0.9 mag=0
RI2_1_0_0 (vs2_1_0_0 vi2_1_0_0) resistor r=50
VI3_1_0_0 (vs3_1_0_0 0) vsource dc=0.9 mag=0
RI3_1_0_0 (vs3_1_0_0 vi3_1_0_0) resistor r=50
VI4_1_0_0 (vs4_1_0_0 0) vsource dc=0.9 mag=0
RI4_1_0_0 (vs4_1_0_0 vi4_1_0_0) resistor r=50
VI5_1_0_0 (vs5_1_0_0 0) vsource dc=0.9 mag=0
RI5_1_0_0 (vs5_1_0_0 vi5_1_0_0) resistor r=50
VI6_1_0_0 (vs6_1_0_0 0) vsource dc=0.9 mag=0
RI6_1_0_0 (vs6_1_0_0 vi6_1_0_0) resistor r=50
VI7_1_0_0 (vs7_1_0_0 0) vsource dc=0.9 mag=0
RI7_1_0_0 (vs7_1_0_0 vi7_1_0_0) resistor r=50
X1_0_0 (vdd1_0_0 0 s2_1_0_0 s1_1_0_0 s0_1_0_0 vi7_1_0_0 vi6_1_0_0 vi5_1_0_0 vi4_1_0_0 vi3_1_0_0 vi2_1_0_0 vi1_1_0_0 vi0_1_0_0 vo1_0_0) input_mux_8to1
CL1_0_0 (vo1_0_0 0) capacitor c=1p
save vo1_0_0 VDD1_0_0:p
save X1_0_0.XSW0.MN:gds
save X1_0_0.XSW0.MP:gds
save X1_0_0.XSW8.MN:gds
save X1_0_0.XSW8.MP:gds
save X1_0_0.XSW12.MN:gds
save X1_0_0.XSW12.MP:gds
VDD1_0_1 (vdsrc1_0_1 0) vsource dc=1.8
RVD1_0_1 (vdsrc1_0_1 vdd1_0_1) resistor r=50
VS0_1_0_1 (ss0_1_0_1 0) vsource dc=0
RS0_1_0_1 (ss0_1_0_1 s0_1_0_1) resistor r=50
VS1_1_0_1 (ss1_1_0_1 0) vsource dc=0
RS1_1_0_1 (ss1_1_0_1 s1_1_0_1) resistor r=50
VS2_1_0_1 (ss2_1_0_1 0) vsource dc=0
RS2_1_0_1 (ss2_1_0_1 s2_1_0_1) resistor r=50
VI0_1_0_1 (vs0_1_0_1 0) vsource dc=0.9 mag=0
RI0_1_0_1 (vs0_1_0_1 vi0_1_0_1) resistor r=50
VI1_1_0_1 (vs1_1_0_1 0) vsource dc=0.9 mag=1
RI1_1_0_1 (vs1_1_0_1 vi1_1_0_1) resistor r=50
VI2_1_0_1 (vs2_1_0_1 0) vsource dc=0.9 mag=0
RI2_1_0_1 (vs2_1_0_1 vi2_1_0_1) resistor r=50
VI3_1_0_1 (vs3_1_0_1 0) vsource dc=0.9 mag=0
RI3_1_0_1 (vs3_1_0_1 vi3_1_0_1) resistor r=50
VI4_1_0_1 (vs4_1_0_1 0) vsource dc=0.9 mag=0
RI4_1_0_1 (vs4_1_0_1 vi4_1_0_1) resistor r=50
VI5_1_0_1 (vs5_1_0_1 0) vsource dc=0.9 mag=0
RI5_1_0_1 (vs5_1_0_1 vi5_1_0_1) resistor r=50
VI6_1_0_1 (vs6_1_0_1 0) vsource dc=0.9 mag=0
RI6_1_0_1 (vs6_1_0_1 vi6_1_0_1) resistor r=50
VI7_1_0_1 (vs7_1_0_1 0) vsource dc=0.9 mag=0
RI7_1_0_1 (vs7_1_0_1 vi7_1_0_1) resistor r=50
X1_0_1 (vdd1_0_1 0 s2_1_0_1 s1_1_0_1 s0_1_0_1 vi7_1_0_1 vi6_1_0_1 vi5_1_0_1 vi4_1_0_1 vi3_1_0_1 vi2_1_0_1 vi1_1_0_1 vi0_1_0_1 vo1_0_1) input_mux_8to1
CL1_0_1 (vo1_0_1 0) capacitor c=1p
save vo1_0_1 VDD1_0_1:p
VDD1_0_2 (vdsrc1_0_2 0) vsource dc=1.8
RVD1_0_2 (vdsrc1_0_2 vdd1_0_2) resistor r=50
VS0_1_0_2 (ss0_1_0_2 0) vsource dc=0
RS0_1_0_2 (ss0_1_0_2 s0_1_0_2) resistor r=50
VS1_1_0_2 (ss1_1_0_2 0) vsource dc=0
RS1_1_0_2 (ss1_1_0_2 s1_1_0_2) resistor r=50
VS2_1_0_2 (ss2_1_0_2 0) vsource dc=0
RS2_1_0_2 (ss2_1_0_2 s2_1_0_2) resistor r=50
VI0_1_0_2 (vs0_1_0_2 0) vsource dc=0.9 mag=0
RI0_1_0_2 (vs0_1_0_2 vi0_1_0_2) resistor r=50
VI1_1_0_2 (vs1_1_0_2 0) vsource dc=0.9 mag=0
RI1_1_0_2 (vs1_1_0_2 vi1_1_0_2) resistor r=50
VI2_1_0_2 (vs2_1_0_2 0) vsource dc=0.9 mag=1
RI2_1_0_2 (vs2_1_0_2 vi2_1_0_2) resistor r=50
VI3_1_0_2 (vs3_1_0_2 0) vsource dc=0.9 mag=0
RI3_1_0_2 (vs3_1_0_2 vi3_1_0_2) resistor r=50
VI4_1_0_2 (vs4_1_0_2 0) vsource dc=0.9 mag=0
RI4_1_0_2 (vs4_1_0_2 vi4_1_0_2) resistor r=50
VI5_1_0_2 (vs5_1_0_2 0) vsource dc=0.9 mag=0
RI5_1_0_2 (vs5_1_0_2 vi5_1_0_2) resistor r=50
VI6_1_0_2 (vs6_1_0_2 0) vsource dc=0.9 mag=0
RI6_1_0_2 (vs6_1_0_2 vi6_1_0_2) resistor r=50
VI7_1_0_2 (vs7_1_0_2 0) vsource dc=0.9 mag=0
RI7_1_0_2 (vs7_1_0_2 vi7_1_0_2) resistor r=50
X1_0_2 (vdd1_0_2 0 s2_1_0_2 s1_1_0_2 s0_1_0_2 vi7_1_0_2 vi6_1_0_2 vi5_1_0_2 vi4_1_0_2 vi3_1_0_2 vi2_1_0_2 vi1_1_0_2 vi0_1_0_2 vo1_0_2) input_mux_8to1
CL1_0_2 (vo1_0_2 0) capacitor c=1p
save vo1_0_2 VDD1_0_2:p
VDD1_0_3 (vdsrc1_0_3 0) vsource dc=1.8
RVD1_0_3 (vdsrc1_0_3 vdd1_0_3) resistor r=50
VS0_1_0_3 (ss0_1_0_3 0) vsource dc=0
RS0_1_0_3 (ss0_1_0_3 s0_1_0_3) resistor r=50
VS1_1_0_3 (ss1_1_0_3 0) vsource dc=0
RS1_1_0_3 (ss1_1_0_3 s1_1_0_3) resistor r=50
VS2_1_0_3 (ss2_1_0_3 0) vsource dc=0
RS2_1_0_3 (ss2_1_0_3 s2_1_0_3) resistor r=50
VI0_1_0_3 (vs0_1_0_3 0) vsource dc=0.9 mag=0
RI0_1_0_3 (vs0_1_0_3 vi0_1_0_3) resistor r=50
VI1_1_0_3 (vs1_1_0_3 0) vsource dc=0.9 mag=0
RI1_1_0_3 (vs1_1_0_3 vi1_1_0_3) resistor r=50
VI2_1_0_3 (vs2_1_0_3 0) vsource dc=0.9 mag=0
RI2_1_0_3 (vs2_1_0_3 vi2_1_0_3) resistor r=50
VI3_1_0_3 (vs3_1_0_3 0) vsource dc=0.9 mag=1
RI3_1_0_3 (vs3_1_0_3 vi3_1_0_3) resistor r=50
VI4_1_0_3 (vs4_1_0_3 0) vsource dc=0.9 mag=0
RI4_1_0_3 (vs4_1_0_3 vi4_1_0_3) resistor r=50
VI5_1_0_3 (vs5_1_0_3 0) vsource dc=0.9 mag=0
RI5_1_0_3 (vs5_1_0_3 vi5_1_0_3) resistor r=50
VI6_1_0_3 (vs6_1_0_3 0) vsource dc=0.9 mag=0
RI6_1_0_3 (vs6_1_0_3 vi6_1_0_3) resistor r=50
VI7_1_0_3 (vs7_1_0_3 0) vsource dc=0.9 mag=0
RI7_1_0_3 (vs7_1_0_3 vi7_1_0_3) resistor r=50
X1_0_3 (vdd1_0_3 0 s2_1_0_3 s1_1_0_3 s0_1_0_3 vi7_1_0_3 vi6_1_0_3 vi5_1_0_3 vi4_1_0_3 vi3_1_0_3 vi2_1_0_3 vi1_1_0_3 vi0_1_0_3 vo1_0_3) input_mux_8to1
CL1_0_3 (vo1_0_3 0) capacitor c=1p
save vo1_0_3 VDD1_0_3:p
VDD1_0_4 (vdsrc1_0_4 0) vsource dc=1.8
RVD1_0_4 (vdsrc1_0_4 vdd1_0_4) resistor r=50
VS0_1_0_4 (ss0_1_0_4 0) vsource dc=0
RS0_1_0_4 (ss0_1_0_4 s0_1_0_4) resistor r=50
VS1_1_0_4 (ss1_1_0_4 0) vsource dc=0
RS1_1_0_4 (ss1_1_0_4 s1_1_0_4) resistor r=50
VS2_1_0_4 (ss2_1_0_4 0) vsource dc=0
RS2_1_0_4 (ss2_1_0_4 s2_1_0_4) resistor r=50
VI0_1_0_4 (vs0_1_0_4 0) vsource dc=0.9 mag=0
RI0_1_0_4 (vs0_1_0_4 vi0_1_0_4) resistor r=50
VI1_1_0_4 (vs1_1_0_4 0) vsource dc=0.9 mag=0
RI1_1_0_4 (vs1_1_0_4 vi1_1_0_4) resistor r=50
VI2_1_0_4 (vs2_1_0_4 0) vsource dc=0.9 mag=0
RI2_1_0_4 (vs2_1_0_4 vi2_1_0_4) resistor r=50
VI3_1_0_4 (vs3_1_0_4 0) vsource dc=0.9 mag=0
RI3_1_0_4 (vs3_1_0_4 vi3_1_0_4) resistor r=50
VI4_1_0_4 (vs4_1_0_4 0) vsource dc=0.9 mag=1
RI4_1_0_4 (vs4_1_0_4 vi4_1_0_4) resistor r=50
VI5_1_0_4 (vs5_1_0_4 0) vsource dc=0.9 mag=0
RI5_1_0_4 (vs5_1_0_4 vi5_1_0_4) resistor r=50
VI6_1_0_4 (vs6_1_0_4 0) vsource dc=0.9 mag=0
RI6_1_0_4 (vs6_1_0_4 vi6_1_0_4) resistor r=50
VI7_1_0_4 (vs7_1_0_4 0) vsource dc=0.9 mag=0
RI7_1_0_4 (vs7_1_0_4 vi7_1_0_4) resistor r=50
X1_0_4 (vdd1_0_4 0 s2_1_0_4 s1_1_0_4 s0_1_0_4 vi7_1_0_4 vi6_1_0_4 vi5_1_0_4 vi4_1_0_4 vi3_1_0_4 vi2_1_0_4 vi1_1_0_4 vi0_1_0_4 vo1_0_4) input_mux_8to1
CL1_0_4 (vo1_0_4 0) capacitor c=1p
save vo1_0_4 VDD1_0_4:p
VDD1_0_5 (vdsrc1_0_5 0) vsource dc=1.8
RVD1_0_5 (vdsrc1_0_5 vdd1_0_5) resistor r=50
VS0_1_0_5 (ss0_1_0_5 0) vsource dc=0
RS0_1_0_5 (ss0_1_0_5 s0_1_0_5) resistor r=50
VS1_1_0_5 (ss1_1_0_5 0) vsource dc=0
RS1_1_0_5 (ss1_1_0_5 s1_1_0_5) resistor r=50
VS2_1_0_5 (ss2_1_0_5 0) vsource dc=0
RS2_1_0_5 (ss2_1_0_5 s2_1_0_5) resistor r=50
VI0_1_0_5 (vs0_1_0_5 0) vsource dc=0.9 mag=0
RI0_1_0_5 (vs0_1_0_5 vi0_1_0_5) resistor r=50
VI1_1_0_5 (vs1_1_0_5 0) vsource dc=0.9 mag=0
RI1_1_0_5 (vs1_1_0_5 vi1_1_0_5) resistor r=50
VI2_1_0_5 (vs2_1_0_5 0) vsource dc=0.9 mag=0
RI2_1_0_5 (vs2_1_0_5 vi2_1_0_5) resistor r=50
VI3_1_0_5 (vs3_1_0_5 0) vsource dc=0.9 mag=0
RI3_1_0_5 (vs3_1_0_5 vi3_1_0_5) resistor r=50
VI4_1_0_5 (vs4_1_0_5 0) vsource dc=0.9 mag=0
RI4_1_0_5 (vs4_1_0_5 vi4_1_0_5) resistor r=50
VI5_1_0_5 (vs5_1_0_5 0) vsource dc=0.9 mag=1
RI5_1_0_5 (vs5_1_0_5 vi5_1_0_5) resistor r=50
VI6_1_0_5 (vs6_1_0_5 0) vsource dc=0.9 mag=0
RI6_1_0_5 (vs6_1_0_5 vi6_1_0_5) resistor r=50
VI7_1_0_5 (vs7_1_0_5 0) vsource dc=0.9 mag=0
RI7_1_0_5 (vs7_1_0_5 vi7_1_0_5) resistor r=50
X1_0_5 (vdd1_0_5 0 s2_1_0_5 s1_1_0_5 s0_1_0_5 vi7_1_0_5 vi6_1_0_5 vi5_1_0_5 vi4_1_0_5 vi3_1_0_5 vi2_1_0_5 vi1_1_0_5 vi0_1_0_5 vo1_0_5) input_mux_8to1
CL1_0_5 (vo1_0_5 0) capacitor c=1p
save vo1_0_5 VDD1_0_5:p
VDD1_0_6 (vdsrc1_0_6 0) vsource dc=1.8
RVD1_0_6 (vdsrc1_0_6 vdd1_0_6) resistor r=50
VS0_1_0_6 (ss0_1_0_6 0) vsource dc=0
RS0_1_0_6 (ss0_1_0_6 s0_1_0_6) resistor r=50
VS1_1_0_6 (ss1_1_0_6 0) vsource dc=0
RS1_1_0_6 (ss1_1_0_6 s1_1_0_6) resistor r=50
VS2_1_0_6 (ss2_1_0_6 0) vsource dc=0
RS2_1_0_6 (ss2_1_0_6 s2_1_0_6) resistor r=50
VI0_1_0_6 (vs0_1_0_6 0) vsource dc=0.9 mag=0
RI0_1_0_6 (vs0_1_0_6 vi0_1_0_6) resistor r=50
VI1_1_0_6 (vs1_1_0_6 0) vsource dc=0.9 mag=0
RI1_1_0_6 (vs1_1_0_6 vi1_1_0_6) resistor r=50
VI2_1_0_6 (vs2_1_0_6 0) vsource dc=0.9 mag=0
RI2_1_0_6 (vs2_1_0_6 vi2_1_0_6) resistor r=50
VI3_1_0_6 (vs3_1_0_6 0) vsource dc=0.9 mag=0
RI3_1_0_6 (vs3_1_0_6 vi3_1_0_6) resistor r=50
VI4_1_0_6 (vs4_1_0_6 0) vsource dc=0.9 mag=0
RI4_1_0_6 (vs4_1_0_6 vi4_1_0_6) resistor r=50
VI5_1_0_6 (vs5_1_0_6 0) vsource dc=0.9 mag=0
RI5_1_0_6 (vs5_1_0_6 vi5_1_0_6) resistor r=50
VI6_1_0_6 (vs6_1_0_6 0) vsource dc=0.9 mag=1
RI6_1_0_6 (vs6_1_0_6 vi6_1_0_6) resistor r=50
VI7_1_0_6 (vs7_1_0_6 0) vsource dc=0.9 mag=0
RI7_1_0_6 (vs7_1_0_6 vi7_1_0_6) resistor r=50
X1_0_6 (vdd1_0_6 0 s2_1_0_6 s1_1_0_6 s0_1_0_6 vi7_1_0_6 vi6_1_0_6 vi5_1_0_6 vi4_1_0_6 vi3_1_0_6 vi2_1_0_6 vi1_1_0_6 vi0_1_0_6 vo1_0_6) input_mux_8to1
CL1_0_6 (vo1_0_6 0) capacitor c=1p
save vo1_0_6 VDD1_0_6:p
VDD1_0_7 (vdsrc1_0_7 0) vsource dc=1.8
RVD1_0_7 (vdsrc1_0_7 vdd1_0_7) resistor r=50
VS0_1_0_7 (ss0_1_0_7 0) vsource dc=0
RS0_1_0_7 (ss0_1_0_7 s0_1_0_7) resistor r=50
VS1_1_0_7 (ss1_1_0_7 0) vsource dc=0
RS1_1_0_7 (ss1_1_0_7 s1_1_0_7) resistor r=50
VS2_1_0_7 (ss2_1_0_7 0) vsource dc=0
RS2_1_0_7 (ss2_1_0_7 s2_1_0_7) resistor r=50
VI0_1_0_7 (vs0_1_0_7 0) vsource dc=0.9 mag=0
RI0_1_0_7 (vs0_1_0_7 vi0_1_0_7) resistor r=50
VI1_1_0_7 (vs1_1_0_7 0) vsource dc=0.9 mag=0
RI1_1_0_7 (vs1_1_0_7 vi1_1_0_7) resistor r=50
VI2_1_0_7 (vs2_1_0_7 0) vsource dc=0.9 mag=0
RI2_1_0_7 (vs2_1_0_7 vi2_1_0_7) resistor r=50
VI3_1_0_7 (vs3_1_0_7 0) vsource dc=0.9 mag=0
RI3_1_0_7 (vs3_1_0_7 vi3_1_0_7) resistor r=50
VI4_1_0_7 (vs4_1_0_7 0) vsource dc=0.9 mag=0
RI4_1_0_7 (vs4_1_0_7 vi4_1_0_7) resistor r=50
VI5_1_0_7 (vs5_1_0_7 0) vsource dc=0.9 mag=0
RI5_1_0_7 (vs5_1_0_7 vi5_1_0_7) resistor r=50
VI6_1_0_7 (vs6_1_0_7 0) vsource dc=0.9 mag=0
RI6_1_0_7 (vs6_1_0_7 vi6_1_0_7) resistor r=50
VI7_1_0_7 (vs7_1_0_7 0) vsource dc=0.9 mag=1
RI7_1_0_7 (vs7_1_0_7 vi7_1_0_7) resistor r=50
X1_0_7 (vdd1_0_7 0 s2_1_0_7 s1_1_0_7 s0_1_0_7 vi7_1_0_7 vi6_1_0_7 vi5_1_0_7 vi4_1_0_7 vi3_1_0_7 vi2_1_0_7 vi1_1_0_7 vi0_1_0_7 vo1_0_7) input_mux_8to1
CL1_0_7 (vo1_0_7 0) capacitor c=1p
save vo1_0_7 VDD1_0_7:p
VDD1_1_0 (vdsrc1_1_0 0) vsource dc=1.8
RVD1_1_0 (vdsrc1_1_0 vdd1_1_0) resistor r=50
VS0_1_1_0 (ss0_1_1_0 0) vsource dc=1.8
RS0_1_1_0 (ss0_1_1_0 s0_1_1_0) resistor r=50
VS1_1_1_0 (ss1_1_1_0 0) vsource dc=0
RS1_1_1_0 (ss1_1_1_0 s1_1_1_0) resistor r=50
VS2_1_1_0 (ss2_1_1_0 0) vsource dc=0
RS2_1_1_0 (ss2_1_1_0 s2_1_1_0) resistor r=50
VI0_1_1_0 (vs0_1_1_0 0) vsource dc=0.9 mag=1
RI0_1_1_0 (vs0_1_1_0 vi0_1_1_0) resistor r=50
VI1_1_1_0 (vs1_1_1_0 0) vsource dc=0.9 mag=0
RI1_1_1_0 (vs1_1_1_0 vi1_1_1_0) resistor r=50
VI2_1_1_0 (vs2_1_1_0 0) vsource dc=0.9 mag=0
RI2_1_1_0 (vs2_1_1_0 vi2_1_1_0) resistor r=50
VI3_1_1_0 (vs3_1_1_0 0) vsource dc=0.9 mag=0
RI3_1_1_0 (vs3_1_1_0 vi3_1_1_0) resistor r=50
VI4_1_1_0 (vs4_1_1_0 0) vsource dc=0.9 mag=0
RI4_1_1_0 (vs4_1_1_0 vi4_1_1_0) resistor r=50
VI5_1_1_0 (vs5_1_1_0 0) vsource dc=0.9 mag=0
RI5_1_1_0 (vs5_1_1_0 vi5_1_1_0) resistor r=50
VI6_1_1_0 (vs6_1_1_0 0) vsource dc=0.9 mag=0
RI6_1_1_0 (vs6_1_1_0 vi6_1_1_0) resistor r=50
VI7_1_1_0 (vs7_1_1_0 0) vsource dc=0.9 mag=0
RI7_1_1_0 (vs7_1_1_0 vi7_1_1_0) resistor r=50
X1_1_0 (vdd1_1_0 0 s2_1_1_0 s1_1_1_0 s0_1_1_0 vi7_1_1_0 vi6_1_1_0 vi5_1_1_0 vi4_1_1_0 vi3_1_1_0 vi2_1_1_0 vi1_1_1_0 vi0_1_1_0 vo1_1_0) input_mux_8to1
CL1_1_0 (vo1_1_0 0) capacitor c=1p
save vo1_1_0 VDD1_1_0:p
VDD1_1_1 (vdsrc1_1_1 0) vsource dc=1.8
RVD1_1_1 (vdsrc1_1_1 vdd1_1_1) resistor r=50
VS0_1_1_1 (ss0_1_1_1 0) vsource dc=1.8
RS0_1_1_1 (ss0_1_1_1 s0_1_1_1) resistor r=50
VS1_1_1_1 (ss1_1_1_1 0) vsource dc=0
RS1_1_1_1 (ss1_1_1_1 s1_1_1_1) resistor r=50
VS2_1_1_1 (ss2_1_1_1 0) vsource dc=0
RS2_1_1_1 (ss2_1_1_1 s2_1_1_1) resistor r=50
VI0_1_1_1 (vs0_1_1_1 0) vsource dc=0.9 mag=0
RI0_1_1_1 (vs0_1_1_1 vi0_1_1_1) resistor r=50
VI1_1_1_1 (vs1_1_1_1 0) vsource dc=0.9 mag=1
RI1_1_1_1 (vs1_1_1_1 vi1_1_1_1) resistor r=50
VI2_1_1_1 (vs2_1_1_1 0) vsource dc=0.9 mag=0
RI2_1_1_1 (vs2_1_1_1 vi2_1_1_1) resistor r=50
VI3_1_1_1 (vs3_1_1_1 0) vsource dc=0.9 mag=0
RI3_1_1_1 (vs3_1_1_1 vi3_1_1_1) resistor r=50
VI4_1_1_1 (vs4_1_1_1 0) vsource dc=0.9 mag=0
RI4_1_1_1 (vs4_1_1_1 vi4_1_1_1) resistor r=50
VI5_1_1_1 (vs5_1_1_1 0) vsource dc=0.9 mag=0
RI5_1_1_1 (vs5_1_1_1 vi5_1_1_1) resistor r=50
VI6_1_1_1 (vs6_1_1_1 0) vsource dc=0.9 mag=0
RI6_1_1_1 (vs6_1_1_1 vi6_1_1_1) resistor r=50
VI7_1_1_1 (vs7_1_1_1 0) vsource dc=0.9 mag=0
RI7_1_1_1 (vs7_1_1_1 vi7_1_1_1) resistor r=50
X1_1_1 (vdd1_1_1 0 s2_1_1_1 s1_1_1_1 s0_1_1_1 vi7_1_1_1 vi6_1_1_1 vi5_1_1_1 vi4_1_1_1 vi3_1_1_1 vi2_1_1_1 vi1_1_1_1 vi0_1_1_1 vo1_1_1) input_mux_8to1
CL1_1_1 (vo1_1_1 0) capacitor c=1p
save vo1_1_1 VDD1_1_1:p
VDD1_1_2 (vdsrc1_1_2 0) vsource dc=1.8
RVD1_1_2 (vdsrc1_1_2 vdd1_1_2) resistor r=50
VS0_1_1_2 (ss0_1_1_2 0) vsource dc=1.8
RS0_1_1_2 (ss0_1_1_2 s0_1_1_2) resistor r=50
VS1_1_1_2 (ss1_1_1_2 0) vsource dc=0
RS1_1_1_2 (ss1_1_1_2 s1_1_1_2) resistor r=50
VS2_1_1_2 (ss2_1_1_2 0) vsource dc=0
RS2_1_1_2 (ss2_1_1_2 s2_1_1_2) resistor r=50
VI0_1_1_2 (vs0_1_1_2 0) vsource dc=0.9 mag=0
RI0_1_1_2 (vs0_1_1_2 vi0_1_1_2) resistor r=50
VI1_1_1_2 (vs1_1_1_2 0) vsource dc=0.9 mag=0
RI1_1_1_2 (vs1_1_1_2 vi1_1_1_2) resistor r=50
VI2_1_1_2 (vs2_1_1_2 0) vsource dc=0.9 mag=1
RI2_1_1_2 (vs2_1_1_2 vi2_1_1_2) resistor r=50
VI3_1_1_2 (vs3_1_1_2 0) vsource dc=0.9 mag=0
RI3_1_1_2 (vs3_1_1_2 vi3_1_1_2) resistor r=50
VI4_1_1_2 (vs4_1_1_2 0) vsource dc=0.9 mag=0
RI4_1_1_2 (vs4_1_1_2 vi4_1_1_2) resistor r=50
VI5_1_1_2 (vs5_1_1_2 0) vsource dc=0.9 mag=0
RI5_1_1_2 (vs5_1_1_2 vi5_1_1_2) resistor r=50
VI6_1_1_2 (vs6_1_1_2 0) vsource dc=0.9 mag=0
RI6_1_1_2 (vs6_1_1_2 vi6_1_1_2) resistor r=50
VI7_1_1_2 (vs7_1_1_2 0) vsource dc=0.9 mag=0
RI7_1_1_2 (vs7_1_1_2 vi7_1_1_2) resistor r=50
X1_1_2 (vdd1_1_2 0 s2_1_1_2 s1_1_1_2 s0_1_1_2 vi7_1_1_2 vi6_1_1_2 vi5_1_1_2 vi4_1_1_2 vi3_1_1_2 vi2_1_1_2 vi1_1_1_2 vi0_1_1_2 vo1_1_2) input_mux_8to1
CL1_1_2 (vo1_1_2 0) capacitor c=1p
save vo1_1_2 VDD1_1_2:p
VDD1_1_3 (vdsrc1_1_3 0) vsource dc=1.8
RVD1_1_3 (vdsrc1_1_3 vdd1_1_3) resistor r=50
VS0_1_1_3 (ss0_1_1_3 0) vsource dc=1.8
RS0_1_1_3 (ss0_1_1_3 s0_1_1_3) resistor r=50
VS1_1_1_3 (ss1_1_1_3 0) vsource dc=0
RS1_1_1_3 (ss1_1_1_3 s1_1_1_3) resistor r=50
VS2_1_1_3 (ss2_1_1_3 0) vsource dc=0
RS2_1_1_3 (ss2_1_1_3 s2_1_1_3) resistor r=50
VI0_1_1_3 (vs0_1_1_3 0) vsource dc=0.9 mag=0
RI0_1_1_3 (vs0_1_1_3 vi0_1_1_3) resistor r=50
VI1_1_1_3 (vs1_1_1_3 0) vsource dc=0.9 mag=0
RI1_1_1_3 (vs1_1_1_3 vi1_1_1_3) resistor r=50
VI2_1_1_3 (vs2_1_1_3 0) vsource dc=0.9 mag=0
RI2_1_1_3 (vs2_1_1_3 vi2_1_1_3) resistor r=50
VI3_1_1_3 (vs3_1_1_3 0) vsource dc=0.9 mag=1
RI3_1_1_3 (vs3_1_1_3 vi3_1_1_3) resistor r=50
VI4_1_1_3 (vs4_1_1_3 0) vsource dc=0.9 mag=0
RI4_1_1_3 (vs4_1_1_3 vi4_1_1_3) resistor r=50
VI5_1_1_3 (vs5_1_1_3 0) vsource dc=0.9 mag=0
RI5_1_1_3 (vs5_1_1_3 vi5_1_1_3) resistor r=50
VI6_1_1_3 (vs6_1_1_3 0) vsource dc=0.9 mag=0
RI6_1_1_3 (vs6_1_1_3 vi6_1_1_3) resistor r=50
VI7_1_1_3 (vs7_1_1_3 0) vsource dc=0.9 mag=0
RI7_1_1_3 (vs7_1_1_3 vi7_1_1_3) resistor r=50
X1_1_3 (vdd1_1_3 0 s2_1_1_3 s1_1_1_3 s0_1_1_3 vi7_1_1_3 vi6_1_1_3 vi5_1_1_3 vi4_1_1_3 vi3_1_1_3 vi2_1_1_3 vi1_1_1_3 vi0_1_1_3 vo1_1_3) input_mux_8to1
CL1_1_3 (vo1_1_3 0) capacitor c=1p
save vo1_1_3 VDD1_1_3:p
VDD1_1_4 (vdsrc1_1_4 0) vsource dc=1.8
RVD1_1_4 (vdsrc1_1_4 vdd1_1_4) resistor r=50
VS0_1_1_4 (ss0_1_1_4 0) vsource dc=1.8
RS0_1_1_4 (ss0_1_1_4 s0_1_1_4) resistor r=50
VS1_1_1_4 (ss1_1_1_4 0) vsource dc=0
RS1_1_1_4 (ss1_1_1_4 s1_1_1_4) resistor r=50
VS2_1_1_4 (ss2_1_1_4 0) vsource dc=0
RS2_1_1_4 (ss2_1_1_4 s2_1_1_4) resistor r=50
VI0_1_1_4 (vs0_1_1_4 0) vsource dc=0.9 mag=0
RI0_1_1_4 (vs0_1_1_4 vi0_1_1_4) resistor r=50
VI1_1_1_4 (vs1_1_1_4 0) vsource dc=0.9 mag=0
RI1_1_1_4 (vs1_1_1_4 vi1_1_1_4) resistor r=50
VI2_1_1_4 (vs2_1_1_4 0) vsource dc=0.9 mag=0
RI2_1_1_4 (vs2_1_1_4 vi2_1_1_4) resistor r=50
VI3_1_1_4 (vs3_1_1_4 0) vsource dc=0.9 mag=0
RI3_1_1_4 (vs3_1_1_4 vi3_1_1_4) resistor r=50
VI4_1_1_4 (vs4_1_1_4 0) vsource dc=0.9 mag=1
RI4_1_1_4 (vs4_1_1_4 vi4_1_1_4) resistor r=50
VI5_1_1_4 (vs5_1_1_4 0) vsource dc=0.9 mag=0
RI5_1_1_4 (vs5_1_1_4 vi5_1_1_4) resistor r=50
VI6_1_1_4 (vs6_1_1_4 0) vsource dc=0.9 mag=0
RI6_1_1_4 (vs6_1_1_4 vi6_1_1_4) resistor r=50
VI7_1_1_4 (vs7_1_1_4 0) vsource dc=0.9 mag=0
RI7_1_1_4 (vs7_1_1_4 vi7_1_1_4) resistor r=50
X1_1_4 (vdd1_1_4 0 s2_1_1_4 s1_1_1_4 s0_1_1_4 vi7_1_1_4 vi6_1_1_4 vi5_1_1_4 vi4_1_1_4 vi3_1_1_4 vi2_1_1_4 vi1_1_1_4 vi0_1_1_4 vo1_1_4) input_mux_8to1
CL1_1_4 (vo1_1_4 0) capacitor c=1p
save vo1_1_4 VDD1_1_4:p
VDD1_1_5 (vdsrc1_1_5 0) vsource dc=1.8
RVD1_1_5 (vdsrc1_1_5 vdd1_1_5) resistor r=50
VS0_1_1_5 (ss0_1_1_5 0) vsource dc=1.8
RS0_1_1_5 (ss0_1_1_5 s0_1_1_5) resistor r=50
VS1_1_1_5 (ss1_1_1_5 0) vsource dc=0
RS1_1_1_5 (ss1_1_1_5 s1_1_1_5) resistor r=50
VS2_1_1_5 (ss2_1_1_5 0) vsource dc=0
RS2_1_1_5 (ss2_1_1_5 s2_1_1_5) resistor r=50
VI0_1_1_5 (vs0_1_1_5 0) vsource dc=0.9 mag=0
RI0_1_1_5 (vs0_1_1_5 vi0_1_1_5) resistor r=50
VI1_1_1_5 (vs1_1_1_5 0) vsource dc=0.9 mag=0
RI1_1_1_5 (vs1_1_1_5 vi1_1_1_5) resistor r=50
VI2_1_1_5 (vs2_1_1_5 0) vsource dc=0.9 mag=0
RI2_1_1_5 (vs2_1_1_5 vi2_1_1_5) resistor r=50
VI3_1_1_5 (vs3_1_1_5 0) vsource dc=0.9 mag=0
RI3_1_1_5 (vs3_1_1_5 vi3_1_1_5) resistor r=50
VI4_1_1_5 (vs4_1_1_5 0) vsource dc=0.9 mag=0
RI4_1_1_5 (vs4_1_1_5 vi4_1_1_5) resistor r=50
VI5_1_1_5 (vs5_1_1_5 0) vsource dc=0.9 mag=1
RI5_1_1_5 (vs5_1_1_5 vi5_1_1_5) resistor r=50
VI6_1_1_5 (vs6_1_1_5 0) vsource dc=0.9 mag=0
RI6_1_1_5 (vs6_1_1_5 vi6_1_1_5) resistor r=50
VI7_1_1_5 (vs7_1_1_5 0) vsource dc=0.9 mag=0
RI7_1_1_5 (vs7_1_1_5 vi7_1_1_5) resistor r=50
X1_1_5 (vdd1_1_5 0 s2_1_1_5 s1_1_1_5 s0_1_1_5 vi7_1_1_5 vi6_1_1_5 vi5_1_1_5 vi4_1_1_5 vi3_1_1_5 vi2_1_1_5 vi1_1_1_5 vi0_1_1_5 vo1_1_5) input_mux_8to1
CL1_1_5 (vo1_1_5 0) capacitor c=1p
save vo1_1_5 VDD1_1_5:p
VDD1_1_6 (vdsrc1_1_6 0) vsource dc=1.8
RVD1_1_6 (vdsrc1_1_6 vdd1_1_6) resistor r=50
VS0_1_1_6 (ss0_1_1_6 0) vsource dc=1.8
RS0_1_1_6 (ss0_1_1_6 s0_1_1_6) resistor r=50
VS1_1_1_6 (ss1_1_1_6 0) vsource dc=0
RS1_1_1_6 (ss1_1_1_6 s1_1_1_6) resistor r=50
VS2_1_1_6 (ss2_1_1_6 0) vsource dc=0
RS2_1_1_6 (ss2_1_1_6 s2_1_1_6) resistor r=50
VI0_1_1_6 (vs0_1_1_6 0) vsource dc=0.9 mag=0
RI0_1_1_6 (vs0_1_1_6 vi0_1_1_6) resistor r=50
VI1_1_1_6 (vs1_1_1_6 0) vsource dc=0.9 mag=0
RI1_1_1_6 (vs1_1_1_6 vi1_1_1_6) resistor r=50
VI2_1_1_6 (vs2_1_1_6 0) vsource dc=0.9 mag=0
RI2_1_1_6 (vs2_1_1_6 vi2_1_1_6) resistor r=50
VI3_1_1_6 (vs3_1_1_6 0) vsource dc=0.9 mag=0
RI3_1_1_6 (vs3_1_1_6 vi3_1_1_6) resistor r=50
VI4_1_1_6 (vs4_1_1_6 0) vsource dc=0.9 mag=0
RI4_1_1_6 (vs4_1_1_6 vi4_1_1_6) resistor r=50
VI5_1_1_6 (vs5_1_1_6 0) vsource dc=0.9 mag=0
RI5_1_1_6 (vs5_1_1_6 vi5_1_1_6) resistor r=50
VI6_1_1_6 (vs6_1_1_6 0) vsource dc=0.9 mag=1
RI6_1_1_6 (vs6_1_1_6 vi6_1_1_6) resistor r=50
VI7_1_1_6 (vs7_1_1_6 0) vsource dc=0.9 mag=0
RI7_1_1_6 (vs7_1_1_6 vi7_1_1_6) resistor r=50
X1_1_6 (vdd1_1_6 0 s2_1_1_6 s1_1_1_6 s0_1_1_6 vi7_1_1_6 vi6_1_1_6 vi5_1_1_6 vi4_1_1_6 vi3_1_1_6 vi2_1_1_6 vi1_1_1_6 vi0_1_1_6 vo1_1_6) input_mux_8to1
CL1_1_6 (vo1_1_6 0) capacitor c=1p
save vo1_1_6 VDD1_1_6:p
VDD1_1_7 (vdsrc1_1_7 0) vsource dc=1.8
RVD1_1_7 (vdsrc1_1_7 vdd1_1_7) resistor r=50
VS0_1_1_7 (ss0_1_1_7 0) vsource dc=1.8
RS0_1_1_7 (ss0_1_1_7 s0_1_1_7) resistor r=50
VS1_1_1_7 (ss1_1_1_7 0) vsource dc=0
RS1_1_1_7 (ss1_1_1_7 s1_1_1_7) resistor r=50
VS2_1_1_7 (ss2_1_1_7 0) vsource dc=0
RS2_1_1_7 (ss2_1_1_7 s2_1_1_7) resistor r=50
VI0_1_1_7 (vs0_1_1_7 0) vsource dc=0.9 mag=0
RI0_1_1_7 (vs0_1_1_7 vi0_1_1_7) resistor r=50
VI1_1_1_7 (vs1_1_1_7 0) vsource dc=0.9 mag=0
RI1_1_1_7 (vs1_1_1_7 vi1_1_1_7) resistor r=50
VI2_1_1_7 (vs2_1_1_7 0) vsource dc=0.9 mag=0
RI2_1_1_7 (vs2_1_1_7 vi2_1_1_7) resistor r=50
VI3_1_1_7 (vs3_1_1_7 0) vsource dc=0.9 mag=0
RI3_1_1_7 (vs3_1_1_7 vi3_1_1_7) resistor r=50
VI4_1_1_7 (vs4_1_1_7 0) vsource dc=0.9 mag=0
RI4_1_1_7 (vs4_1_1_7 vi4_1_1_7) resistor r=50
VI5_1_1_7 (vs5_1_1_7 0) vsource dc=0.9 mag=0
RI5_1_1_7 (vs5_1_1_7 vi5_1_1_7) resistor r=50
VI6_1_1_7 (vs6_1_1_7 0) vsource dc=0.9 mag=0
RI6_1_1_7 (vs6_1_1_7 vi6_1_1_7) resistor r=50
VI7_1_1_7 (vs7_1_1_7 0) vsource dc=0.9 mag=1
RI7_1_1_7 (vs7_1_1_7 vi7_1_1_7) resistor r=50
X1_1_7 (vdd1_1_7 0 s2_1_1_7 s1_1_1_7 s0_1_1_7 vi7_1_1_7 vi6_1_1_7 vi5_1_1_7 vi4_1_1_7 vi3_1_1_7 vi2_1_1_7 vi1_1_1_7 vi0_1_1_7 vo1_1_7) input_mux_8to1
CL1_1_7 (vo1_1_7 0) capacitor c=1p
save vo1_1_7 VDD1_1_7:p
VDD1_2_0 (vdsrc1_2_0 0) vsource dc=1.8
RVD1_2_0 (vdsrc1_2_0 vdd1_2_0) resistor r=50
VS0_1_2_0 (ss0_1_2_0 0) vsource dc=0
RS0_1_2_0 (ss0_1_2_0 s0_1_2_0) resistor r=50
VS1_1_2_0 (ss1_1_2_0 0) vsource dc=1.8
RS1_1_2_0 (ss1_1_2_0 s1_1_2_0) resistor r=50
VS2_1_2_0 (ss2_1_2_0 0) vsource dc=0
RS2_1_2_0 (ss2_1_2_0 s2_1_2_0) resistor r=50
VI0_1_2_0 (vs0_1_2_0 0) vsource dc=0.9 mag=1
RI0_1_2_0 (vs0_1_2_0 vi0_1_2_0) resistor r=50
VI1_1_2_0 (vs1_1_2_0 0) vsource dc=0.9 mag=0
RI1_1_2_0 (vs1_1_2_0 vi1_1_2_0) resistor r=50
VI2_1_2_0 (vs2_1_2_0 0) vsource dc=0.9 mag=0
RI2_1_2_0 (vs2_1_2_0 vi2_1_2_0) resistor r=50
VI3_1_2_0 (vs3_1_2_0 0) vsource dc=0.9 mag=0
RI3_1_2_0 (vs3_1_2_0 vi3_1_2_0) resistor r=50
VI4_1_2_0 (vs4_1_2_0 0) vsource dc=0.9 mag=0
RI4_1_2_0 (vs4_1_2_0 vi4_1_2_0) resistor r=50
VI5_1_2_0 (vs5_1_2_0 0) vsource dc=0.9 mag=0
RI5_1_2_0 (vs5_1_2_0 vi5_1_2_0) resistor r=50
VI6_1_2_0 (vs6_1_2_0 0) vsource dc=0.9 mag=0
RI6_1_2_0 (vs6_1_2_0 vi6_1_2_0) resistor r=50
VI7_1_2_0 (vs7_1_2_0 0) vsource dc=0.9 mag=0
RI7_1_2_0 (vs7_1_2_0 vi7_1_2_0) resistor r=50
X1_2_0 (vdd1_2_0 0 s2_1_2_0 s1_1_2_0 s0_1_2_0 vi7_1_2_0 vi6_1_2_0 vi5_1_2_0 vi4_1_2_0 vi3_1_2_0 vi2_1_2_0 vi1_1_2_0 vi0_1_2_0 vo1_2_0) input_mux_8to1
CL1_2_0 (vo1_2_0 0) capacitor c=1p
save vo1_2_0 VDD1_2_0:p
VDD1_2_1 (vdsrc1_2_1 0) vsource dc=1.8
RVD1_2_1 (vdsrc1_2_1 vdd1_2_1) resistor r=50
VS0_1_2_1 (ss0_1_2_1 0) vsource dc=0
RS0_1_2_1 (ss0_1_2_1 s0_1_2_1) resistor r=50
VS1_1_2_1 (ss1_1_2_1 0) vsource dc=1.8
RS1_1_2_1 (ss1_1_2_1 s1_1_2_1) resistor r=50
VS2_1_2_1 (ss2_1_2_1 0) vsource dc=0
RS2_1_2_1 (ss2_1_2_1 s2_1_2_1) resistor r=50
VI0_1_2_1 (vs0_1_2_1 0) vsource dc=0.9 mag=0
RI0_1_2_1 (vs0_1_2_1 vi0_1_2_1) resistor r=50
VI1_1_2_1 (vs1_1_2_1 0) vsource dc=0.9 mag=1
RI1_1_2_1 (vs1_1_2_1 vi1_1_2_1) resistor r=50
VI2_1_2_1 (vs2_1_2_1 0) vsource dc=0.9 mag=0
RI2_1_2_1 (vs2_1_2_1 vi2_1_2_1) resistor r=50
VI3_1_2_1 (vs3_1_2_1 0) vsource dc=0.9 mag=0
RI3_1_2_1 (vs3_1_2_1 vi3_1_2_1) resistor r=50
VI4_1_2_1 (vs4_1_2_1 0) vsource dc=0.9 mag=0
RI4_1_2_1 (vs4_1_2_1 vi4_1_2_1) resistor r=50
VI5_1_2_1 (vs5_1_2_1 0) vsource dc=0.9 mag=0
RI5_1_2_1 (vs5_1_2_1 vi5_1_2_1) resistor r=50
VI6_1_2_1 (vs6_1_2_1 0) vsource dc=0.9 mag=0
RI6_1_2_1 (vs6_1_2_1 vi6_1_2_1) resistor r=50
VI7_1_2_1 (vs7_1_2_1 0) vsource dc=0.9 mag=0
RI7_1_2_1 (vs7_1_2_1 vi7_1_2_1) resistor r=50
X1_2_1 (vdd1_2_1 0 s2_1_2_1 s1_1_2_1 s0_1_2_1 vi7_1_2_1 vi6_1_2_1 vi5_1_2_1 vi4_1_2_1 vi3_1_2_1 vi2_1_2_1 vi1_1_2_1 vi0_1_2_1 vo1_2_1) input_mux_8to1
CL1_2_1 (vo1_2_1 0) capacitor c=1p
save vo1_2_1 VDD1_2_1:p
VDD1_2_2 (vdsrc1_2_2 0) vsource dc=1.8
RVD1_2_2 (vdsrc1_2_2 vdd1_2_2) resistor r=50
VS0_1_2_2 (ss0_1_2_2 0) vsource dc=0
RS0_1_2_2 (ss0_1_2_2 s0_1_2_2) resistor r=50
VS1_1_2_2 (ss1_1_2_2 0) vsource dc=1.8
RS1_1_2_2 (ss1_1_2_2 s1_1_2_2) resistor r=50
VS2_1_2_2 (ss2_1_2_2 0) vsource dc=0
RS2_1_2_2 (ss2_1_2_2 s2_1_2_2) resistor r=50
VI0_1_2_2 (vs0_1_2_2 0) vsource dc=0.9 mag=0
RI0_1_2_2 (vs0_1_2_2 vi0_1_2_2) resistor r=50
VI1_1_2_2 (vs1_1_2_2 0) vsource dc=0.9 mag=0
RI1_1_2_2 (vs1_1_2_2 vi1_1_2_2) resistor r=50
VI2_1_2_2 (vs2_1_2_2 0) vsource dc=0.9 mag=1
RI2_1_2_2 (vs2_1_2_2 vi2_1_2_2) resistor r=50
VI3_1_2_2 (vs3_1_2_2 0) vsource dc=0.9 mag=0
RI3_1_2_2 (vs3_1_2_2 vi3_1_2_2) resistor r=50
VI4_1_2_2 (vs4_1_2_2 0) vsource dc=0.9 mag=0
RI4_1_2_2 (vs4_1_2_2 vi4_1_2_2) resistor r=50
VI5_1_2_2 (vs5_1_2_2 0) vsource dc=0.9 mag=0
RI5_1_2_2 (vs5_1_2_2 vi5_1_2_2) resistor r=50
VI6_1_2_2 (vs6_1_2_2 0) vsource dc=0.9 mag=0
RI6_1_2_2 (vs6_1_2_2 vi6_1_2_2) resistor r=50
VI7_1_2_2 (vs7_1_2_2 0) vsource dc=0.9 mag=0
RI7_1_2_2 (vs7_1_2_2 vi7_1_2_2) resistor r=50
X1_2_2 (vdd1_2_2 0 s2_1_2_2 s1_1_2_2 s0_1_2_2 vi7_1_2_2 vi6_1_2_2 vi5_1_2_2 vi4_1_2_2 vi3_1_2_2 vi2_1_2_2 vi1_1_2_2 vi0_1_2_2 vo1_2_2) input_mux_8to1
CL1_2_2 (vo1_2_2 0) capacitor c=1p
save vo1_2_2 VDD1_2_2:p
VDD1_2_3 (vdsrc1_2_3 0) vsource dc=1.8
RVD1_2_3 (vdsrc1_2_3 vdd1_2_3) resistor r=50
VS0_1_2_3 (ss0_1_2_3 0) vsource dc=0
RS0_1_2_3 (ss0_1_2_3 s0_1_2_3) resistor r=50
VS1_1_2_3 (ss1_1_2_3 0) vsource dc=1.8
RS1_1_2_3 (ss1_1_2_3 s1_1_2_3) resistor r=50
VS2_1_2_3 (ss2_1_2_3 0) vsource dc=0
RS2_1_2_3 (ss2_1_2_3 s2_1_2_3) resistor r=50
VI0_1_2_3 (vs0_1_2_3 0) vsource dc=0.9 mag=0
RI0_1_2_3 (vs0_1_2_3 vi0_1_2_3) resistor r=50
VI1_1_2_3 (vs1_1_2_3 0) vsource dc=0.9 mag=0
RI1_1_2_3 (vs1_1_2_3 vi1_1_2_3) resistor r=50
VI2_1_2_3 (vs2_1_2_3 0) vsource dc=0.9 mag=0
RI2_1_2_3 (vs2_1_2_3 vi2_1_2_3) resistor r=50
VI3_1_2_3 (vs3_1_2_3 0) vsource dc=0.9 mag=1
RI3_1_2_3 (vs3_1_2_3 vi3_1_2_3) resistor r=50
VI4_1_2_3 (vs4_1_2_3 0) vsource dc=0.9 mag=0
RI4_1_2_3 (vs4_1_2_3 vi4_1_2_3) resistor r=50
VI5_1_2_3 (vs5_1_2_3 0) vsource dc=0.9 mag=0
RI5_1_2_3 (vs5_1_2_3 vi5_1_2_3) resistor r=50
VI6_1_2_3 (vs6_1_2_3 0) vsource dc=0.9 mag=0
RI6_1_2_3 (vs6_1_2_3 vi6_1_2_3) resistor r=50
VI7_1_2_3 (vs7_1_2_3 0) vsource dc=0.9 mag=0
RI7_1_2_3 (vs7_1_2_3 vi7_1_2_3) resistor r=50
X1_2_3 (vdd1_2_3 0 s2_1_2_3 s1_1_2_3 s0_1_2_3 vi7_1_2_3 vi6_1_2_3 vi5_1_2_3 vi4_1_2_3 vi3_1_2_3 vi2_1_2_3 vi1_1_2_3 vi0_1_2_3 vo1_2_3) input_mux_8to1
CL1_2_3 (vo1_2_3 0) capacitor c=1p
save vo1_2_3 VDD1_2_3:p
VDD1_2_4 (vdsrc1_2_4 0) vsource dc=1.8
RVD1_2_4 (vdsrc1_2_4 vdd1_2_4) resistor r=50
VS0_1_2_4 (ss0_1_2_4 0) vsource dc=0
RS0_1_2_4 (ss0_1_2_4 s0_1_2_4) resistor r=50
VS1_1_2_4 (ss1_1_2_4 0) vsource dc=1.8
RS1_1_2_4 (ss1_1_2_4 s1_1_2_4) resistor r=50
VS2_1_2_4 (ss2_1_2_4 0) vsource dc=0
RS2_1_2_4 (ss2_1_2_4 s2_1_2_4) resistor r=50
VI0_1_2_4 (vs0_1_2_4 0) vsource dc=0.9 mag=0
RI0_1_2_4 (vs0_1_2_4 vi0_1_2_4) resistor r=50
VI1_1_2_4 (vs1_1_2_4 0) vsource dc=0.9 mag=0
RI1_1_2_4 (vs1_1_2_4 vi1_1_2_4) resistor r=50
VI2_1_2_4 (vs2_1_2_4 0) vsource dc=0.9 mag=0
RI2_1_2_4 (vs2_1_2_4 vi2_1_2_4) resistor r=50
VI3_1_2_4 (vs3_1_2_4 0) vsource dc=0.9 mag=0
RI3_1_2_4 (vs3_1_2_4 vi3_1_2_4) resistor r=50
VI4_1_2_4 (vs4_1_2_4 0) vsource dc=0.9 mag=1
RI4_1_2_4 (vs4_1_2_4 vi4_1_2_4) resistor r=50
VI5_1_2_4 (vs5_1_2_4 0) vsource dc=0.9 mag=0
RI5_1_2_4 (vs5_1_2_4 vi5_1_2_4) resistor r=50
VI6_1_2_4 (vs6_1_2_4 0) vsource dc=0.9 mag=0
RI6_1_2_4 (vs6_1_2_4 vi6_1_2_4) resistor r=50
VI7_1_2_4 (vs7_1_2_4 0) vsource dc=0.9 mag=0
RI7_1_2_4 (vs7_1_2_4 vi7_1_2_4) resistor r=50
X1_2_4 (vdd1_2_4 0 s2_1_2_4 s1_1_2_4 s0_1_2_4 vi7_1_2_4 vi6_1_2_4 vi5_1_2_4 vi4_1_2_4 vi3_1_2_4 vi2_1_2_4 vi1_1_2_4 vi0_1_2_4 vo1_2_4) input_mux_8to1
CL1_2_4 (vo1_2_4 0) capacitor c=1p
save vo1_2_4 VDD1_2_4:p
VDD1_2_5 (vdsrc1_2_5 0) vsource dc=1.8
RVD1_2_5 (vdsrc1_2_5 vdd1_2_5) resistor r=50
VS0_1_2_5 (ss0_1_2_5 0) vsource dc=0
RS0_1_2_5 (ss0_1_2_5 s0_1_2_5) resistor r=50
VS1_1_2_5 (ss1_1_2_5 0) vsource dc=1.8
RS1_1_2_5 (ss1_1_2_5 s1_1_2_5) resistor r=50
VS2_1_2_5 (ss2_1_2_5 0) vsource dc=0
RS2_1_2_5 (ss2_1_2_5 s2_1_2_5) resistor r=50
VI0_1_2_5 (vs0_1_2_5 0) vsource dc=0.9 mag=0
RI0_1_2_5 (vs0_1_2_5 vi0_1_2_5) resistor r=50
VI1_1_2_5 (vs1_1_2_5 0) vsource dc=0.9 mag=0
RI1_1_2_5 (vs1_1_2_5 vi1_1_2_5) resistor r=50
VI2_1_2_5 (vs2_1_2_5 0) vsource dc=0.9 mag=0
RI2_1_2_5 (vs2_1_2_5 vi2_1_2_5) resistor r=50
VI3_1_2_5 (vs3_1_2_5 0) vsource dc=0.9 mag=0
RI3_1_2_5 (vs3_1_2_5 vi3_1_2_5) resistor r=50
VI4_1_2_5 (vs4_1_2_5 0) vsource dc=0.9 mag=0
RI4_1_2_5 (vs4_1_2_5 vi4_1_2_5) resistor r=50
VI5_1_2_5 (vs5_1_2_5 0) vsource dc=0.9 mag=1
RI5_1_2_5 (vs5_1_2_5 vi5_1_2_5) resistor r=50
VI6_1_2_5 (vs6_1_2_5 0) vsource dc=0.9 mag=0
RI6_1_2_5 (vs6_1_2_5 vi6_1_2_5) resistor r=50
VI7_1_2_5 (vs7_1_2_5 0) vsource dc=0.9 mag=0
RI7_1_2_5 (vs7_1_2_5 vi7_1_2_5) resistor r=50
X1_2_5 (vdd1_2_5 0 s2_1_2_5 s1_1_2_5 s0_1_2_5 vi7_1_2_5 vi6_1_2_5 vi5_1_2_5 vi4_1_2_5 vi3_1_2_5 vi2_1_2_5 vi1_1_2_5 vi0_1_2_5 vo1_2_5) input_mux_8to1
CL1_2_5 (vo1_2_5 0) capacitor c=1p
save vo1_2_5 VDD1_2_5:p
VDD1_2_6 (vdsrc1_2_6 0) vsource dc=1.8
RVD1_2_6 (vdsrc1_2_6 vdd1_2_6) resistor r=50
VS0_1_2_6 (ss0_1_2_6 0) vsource dc=0
RS0_1_2_6 (ss0_1_2_6 s0_1_2_6) resistor r=50
VS1_1_2_6 (ss1_1_2_6 0) vsource dc=1.8
RS1_1_2_6 (ss1_1_2_6 s1_1_2_6) resistor r=50
VS2_1_2_6 (ss2_1_2_6 0) vsource dc=0
RS2_1_2_6 (ss2_1_2_6 s2_1_2_6) resistor r=50
VI0_1_2_6 (vs0_1_2_6 0) vsource dc=0.9 mag=0
RI0_1_2_6 (vs0_1_2_6 vi0_1_2_6) resistor r=50
VI1_1_2_6 (vs1_1_2_6 0) vsource dc=0.9 mag=0
RI1_1_2_6 (vs1_1_2_6 vi1_1_2_6) resistor r=50
VI2_1_2_6 (vs2_1_2_6 0) vsource dc=0.9 mag=0
RI2_1_2_6 (vs2_1_2_6 vi2_1_2_6) resistor r=50
VI3_1_2_6 (vs3_1_2_6 0) vsource dc=0.9 mag=0
RI3_1_2_6 (vs3_1_2_6 vi3_1_2_6) resistor r=50
VI4_1_2_6 (vs4_1_2_6 0) vsource dc=0.9 mag=0
RI4_1_2_6 (vs4_1_2_6 vi4_1_2_6) resistor r=50
VI5_1_2_6 (vs5_1_2_6 0) vsource dc=0.9 mag=0
RI5_1_2_6 (vs5_1_2_6 vi5_1_2_6) resistor r=50
VI6_1_2_6 (vs6_1_2_6 0) vsource dc=0.9 mag=1
RI6_1_2_6 (vs6_1_2_6 vi6_1_2_6) resistor r=50
VI7_1_2_6 (vs7_1_2_6 0) vsource dc=0.9 mag=0
RI7_1_2_6 (vs7_1_2_6 vi7_1_2_6) resistor r=50
X1_2_6 (vdd1_2_6 0 s2_1_2_6 s1_1_2_6 s0_1_2_6 vi7_1_2_6 vi6_1_2_6 vi5_1_2_6 vi4_1_2_6 vi3_1_2_6 vi2_1_2_6 vi1_1_2_6 vi0_1_2_6 vo1_2_6) input_mux_8to1
CL1_2_6 (vo1_2_6 0) capacitor c=1p
save vo1_2_6 VDD1_2_6:p
VDD1_2_7 (vdsrc1_2_7 0) vsource dc=1.8
RVD1_2_7 (vdsrc1_2_7 vdd1_2_7) resistor r=50
VS0_1_2_7 (ss0_1_2_7 0) vsource dc=0
RS0_1_2_7 (ss0_1_2_7 s0_1_2_7) resistor r=50
VS1_1_2_7 (ss1_1_2_7 0) vsource dc=1.8
RS1_1_2_7 (ss1_1_2_7 s1_1_2_7) resistor r=50
VS2_1_2_7 (ss2_1_2_7 0) vsource dc=0
RS2_1_2_7 (ss2_1_2_7 s2_1_2_7) resistor r=50
VI0_1_2_7 (vs0_1_2_7 0) vsource dc=0.9 mag=0
RI0_1_2_7 (vs0_1_2_7 vi0_1_2_7) resistor r=50
VI1_1_2_7 (vs1_1_2_7 0) vsource dc=0.9 mag=0
RI1_1_2_7 (vs1_1_2_7 vi1_1_2_7) resistor r=50
VI2_1_2_7 (vs2_1_2_7 0) vsource dc=0.9 mag=0
RI2_1_2_7 (vs2_1_2_7 vi2_1_2_7) resistor r=50
VI3_1_2_7 (vs3_1_2_7 0) vsource dc=0.9 mag=0
RI3_1_2_7 (vs3_1_2_7 vi3_1_2_7) resistor r=50
VI4_1_2_7 (vs4_1_2_7 0) vsource dc=0.9 mag=0
RI4_1_2_7 (vs4_1_2_7 vi4_1_2_7) resistor r=50
VI5_1_2_7 (vs5_1_2_7 0) vsource dc=0.9 mag=0
RI5_1_2_7 (vs5_1_2_7 vi5_1_2_7) resistor r=50
VI6_1_2_7 (vs6_1_2_7 0) vsource dc=0.9 mag=0
RI6_1_2_7 (vs6_1_2_7 vi6_1_2_7) resistor r=50
VI7_1_2_7 (vs7_1_2_7 0) vsource dc=0.9 mag=1
RI7_1_2_7 (vs7_1_2_7 vi7_1_2_7) resistor r=50
X1_2_7 (vdd1_2_7 0 s2_1_2_7 s1_1_2_7 s0_1_2_7 vi7_1_2_7 vi6_1_2_7 vi5_1_2_7 vi4_1_2_7 vi3_1_2_7 vi2_1_2_7 vi1_1_2_7 vi0_1_2_7 vo1_2_7) input_mux_8to1
CL1_2_7 (vo1_2_7 0) capacitor c=1p
save vo1_2_7 VDD1_2_7:p
VDD1_3_0 (vdsrc1_3_0 0) vsource dc=1.8
RVD1_3_0 (vdsrc1_3_0 vdd1_3_0) resistor r=50
VS0_1_3_0 (ss0_1_3_0 0) vsource dc=1.8
RS0_1_3_0 (ss0_1_3_0 s0_1_3_0) resistor r=50
VS1_1_3_0 (ss1_1_3_0 0) vsource dc=1.8
RS1_1_3_0 (ss1_1_3_0 s1_1_3_0) resistor r=50
VS2_1_3_0 (ss2_1_3_0 0) vsource dc=0
RS2_1_3_0 (ss2_1_3_0 s2_1_3_0) resistor r=50
VI0_1_3_0 (vs0_1_3_0 0) vsource dc=0.9 mag=1
RI0_1_3_0 (vs0_1_3_0 vi0_1_3_0) resistor r=50
VI1_1_3_0 (vs1_1_3_0 0) vsource dc=0.9 mag=0
RI1_1_3_0 (vs1_1_3_0 vi1_1_3_0) resistor r=50
VI2_1_3_0 (vs2_1_3_0 0) vsource dc=0.9 mag=0
RI2_1_3_0 (vs2_1_3_0 vi2_1_3_0) resistor r=50
VI3_1_3_0 (vs3_1_3_0 0) vsource dc=0.9 mag=0
RI3_1_3_0 (vs3_1_3_0 vi3_1_3_0) resistor r=50
VI4_1_3_0 (vs4_1_3_0 0) vsource dc=0.9 mag=0
RI4_1_3_0 (vs4_1_3_0 vi4_1_3_0) resistor r=50
VI5_1_3_0 (vs5_1_3_0 0) vsource dc=0.9 mag=0
RI5_1_3_0 (vs5_1_3_0 vi5_1_3_0) resistor r=50
VI6_1_3_0 (vs6_1_3_0 0) vsource dc=0.9 mag=0
RI6_1_3_0 (vs6_1_3_0 vi6_1_3_0) resistor r=50
VI7_1_3_0 (vs7_1_3_0 0) vsource dc=0.9 mag=0
RI7_1_3_0 (vs7_1_3_0 vi7_1_3_0) resistor r=50
X1_3_0 (vdd1_3_0 0 s2_1_3_0 s1_1_3_0 s0_1_3_0 vi7_1_3_0 vi6_1_3_0 vi5_1_3_0 vi4_1_3_0 vi3_1_3_0 vi2_1_3_0 vi1_1_3_0 vi0_1_3_0 vo1_3_0) input_mux_8to1
CL1_3_0 (vo1_3_0 0) capacitor c=1p
save vo1_3_0 VDD1_3_0:p
VDD1_3_1 (vdsrc1_3_1 0) vsource dc=1.8
RVD1_3_1 (vdsrc1_3_1 vdd1_3_1) resistor r=50
VS0_1_3_1 (ss0_1_3_1 0) vsource dc=1.8
RS0_1_3_1 (ss0_1_3_1 s0_1_3_1) resistor r=50
VS1_1_3_1 (ss1_1_3_1 0) vsource dc=1.8
RS1_1_3_1 (ss1_1_3_1 s1_1_3_1) resistor r=50
VS2_1_3_1 (ss2_1_3_1 0) vsource dc=0
RS2_1_3_1 (ss2_1_3_1 s2_1_3_1) resistor r=50
VI0_1_3_1 (vs0_1_3_1 0) vsource dc=0.9 mag=0
RI0_1_3_1 (vs0_1_3_1 vi0_1_3_1) resistor r=50
VI1_1_3_1 (vs1_1_3_1 0) vsource dc=0.9 mag=1
RI1_1_3_1 (vs1_1_3_1 vi1_1_3_1) resistor r=50
VI2_1_3_1 (vs2_1_3_1 0) vsource dc=0.9 mag=0
RI2_1_3_1 (vs2_1_3_1 vi2_1_3_1) resistor r=50
VI3_1_3_1 (vs3_1_3_1 0) vsource dc=0.9 mag=0
RI3_1_3_1 (vs3_1_3_1 vi3_1_3_1) resistor r=50
VI4_1_3_1 (vs4_1_3_1 0) vsource dc=0.9 mag=0
RI4_1_3_1 (vs4_1_3_1 vi4_1_3_1) resistor r=50
VI5_1_3_1 (vs5_1_3_1 0) vsource dc=0.9 mag=0
RI5_1_3_1 (vs5_1_3_1 vi5_1_3_1) resistor r=50
VI6_1_3_1 (vs6_1_3_1 0) vsource dc=0.9 mag=0
RI6_1_3_1 (vs6_1_3_1 vi6_1_3_1) resistor r=50
VI7_1_3_1 (vs7_1_3_1 0) vsource dc=0.9 mag=0
RI7_1_3_1 (vs7_1_3_1 vi7_1_3_1) resistor r=50
X1_3_1 (vdd1_3_1 0 s2_1_3_1 s1_1_3_1 s0_1_3_1 vi7_1_3_1 vi6_1_3_1 vi5_1_3_1 vi4_1_3_1 vi3_1_3_1 vi2_1_3_1 vi1_1_3_1 vi0_1_3_1 vo1_3_1) input_mux_8to1
CL1_3_1 (vo1_3_1 0) capacitor c=1p
save vo1_3_1 VDD1_3_1:p
VDD1_3_2 (vdsrc1_3_2 0) vsource dc=1.8
RVD1_3_2 (vdsrc1_3_2 vdd1_3_2) resistor r=50
VS0_1_3_2 (ss0_1_3_2 0) vsource dc=1.8
RS0_1_3_2 (ss0_1_3_2 s0_1_3_2) resistor r=50
VS1_1_3_2 (ss1_1_3_2 0) vsource dc=1.8
RS1_1_3_2 (ss1_1_3_2 s1_1_3_2) resistor r=50
VS2_1_3_2 (ss2_1_3_2 0) vsource dc=0
RS2_1_3_2 (ss2_1_3_2 s2_1_3_2) resistor r=50
VI0_1_3_2 (vs0_1_3_2 0) vsource dc=0.9 mag=0
RI0_1_3_2 (vs0_1_3_2 vi0_1_3_2) resistor r=50
VI1_1_3_2 (vs1_1_3_2 0) vsource dc=0.9 mag=0
RI1_1_3_2 (vs1_1_3_2 vi1_1_3_2) resistor r=50
VI2_1_3_2 (vs2_1_3_2 0) vsource dc=0.9 mag=1
RI2_1_3_2 (vs2_1_3_2 vi2_1_3_2) resistor r=50
VI3_1_3_2 (vs3_1_3_2 0) vsource dc=0.9 mag=0
RI3_1_3_2 (vs3_1_3_2 vi3_1_3_2) resistor r=50
VI4_1_3_2 (vs4_1_3_2 0) vsource dc=0.9 mag=0
RI4_1_3_2 (vs4_1_3_2 vi4_1_3_2) resistor r=50
VI5_1_3_2 (vs5_1_3_2 0) vsource dc=0.9 mag=0
RI5_1_3_2 (vs5_1_3_2 vi5_1_3_2) resistor r=50
VI6_1_3_2 (vs6_1_3_2 0) vsource dc=0.9 mag=0
RI6_1_3_2 (vs6_1_3_2 vi6_1_3_2) resistor r=50
VI7_1_3_2 (vs7_1_3_2 0) vsource dc=0.9 mag=0
RI7_1_3_2 (vs7_1_3_2 vi7_1_3_2) resistor r=50
X1_3_2 (vdd1_3_2 0 s2_1_3_2 s1_1_3_2 s0_1_3_2 vi7_1_3_2 vi6_1_3_2 vi5_1_3_2 vi4_1_3_2 vi3_1_3_2 vi2_1_3_2 vi1_1_3_2 vi0_1_3_2 vo1_3_2) input_mux_8to1
CL1_3_2 (vo1_3_2 0) capacitor c=1p
save vo1_3_2 VDD1_3_2:p
VDD1_3_3 (vdsrc1_3_3 0) vsource dc=1.8
RVD1_3_3 (vdsrc1_3_3 vdd1_3_3) resistor r=50
VS0_1_3_3 (ss0_1_3_3 0) vsource dc=1.8
RS0_1_3_3 (ss0_1_3_3 s0_1_3_3) resistor r=50
VS1_1_3_3 (ss1_1_3_3 0) vsource dc=1.8
RS1_1_3_3 (ss1_1_3_3 s1_1_3_3) resistor r=50
VS2_1_3_3 (ss2_1_3_3 0) vsource dc=0
RS2_1_3_3 (ss2_1_3_3 s2_1_3_3) resistor r=50
VI0_1_3_3 (vs0_1_3_3 0) vsource dc=0.9 mag=0
RI0_1_3_3 (vs0_1_3_3 vi0_1_3_3) resistor r=50
VI1_1_3_3 (vs1_1_3_3 0) vsource dc=0.9 mag=0
RI1_1_3_3 (vs1_1_3_3 vi1_1_3_3) resistor r=50
VI2_1_3_3 (vs2_1_3_3 0) vsource dc=0.9 mag=0
RI2_1_3_3 (vs2_1_3_3 vi2_1_3_3) resistor r=50
VI3_1_3_3 (vs3_1_3_3 0) vsource dc=0.9 mag=1
RI3_1_3_3 (vs3_1_3_3 vi3_1_3_3) resistor r=50
VI4_1_3_3 (vs4_1_3_3 0) vsource dc=0.9 mag=0
RI4_1_3_3 (vs4_1_3_3 vi4_1_3_3) resistor r=50
VI5_1_3_3 (vs5_1_3_3 0) vsource dc=0.9 mag=0
RI5_1_3_3 (vs5_1_3_3 vi5_1_3_3) resistor r=50
VI6_1_3_3 (vs6_1_3_3 0) vsource dc=0.9 mag=0
RI6_1_3_3 (vs6_1_3_3 vi6_1_3_3) resistor r=50
VI7_1_3_3 (vs7_1_3_3 0) vsource dc=0.9 mag=0
RI7_1_3_3 (vs7_1_3_3 vi7_1_3_3) resistor r=50
X1_3_3 (vdd1_3_3 0 s2_1_3_3 s1_1_3_3 s0_1_3_3 vi7_1_3_3 vi6_1_3_3 vi5_1_3_3 vi4_1_3_3 vi3_1_3_3 vi2_1_3_3 vi1_1_3_3 vi0_1_3_3 vo1_3_3) input_mux_8to1
CL1_3_3 (vo1_3_3 0) capacitor c=1p
save vo1_3_3 VDD1_3_3:p
VDD1_3_4 (vdsrc1_3_4 0) vsource dc=1.8
RVD1_3_4 (vdsrc1_3_4 vdd1_3_4) resistor r=50
VS0_1_3_4 (ss0_1_3_4 0) vsource dc=1.8
RS0_1_3_4 (ss0_1_3_4 s0_1_3_4) resistor r=50
VS1_1_3_4 (ss1_1_3_4 0) vsource dc=1.8
RS1_1_3_4 (ss1_1_3_4 s1_1_3_4) resistor r=50
VS2_1_3_4 (ss2_1_3_4 0) vsource dc=0
RS2_1_3_4 (ss2_1_3_4 s2_1_3_4) resistor r=50
VI0_1_3_4 (vs0_1_3_4 0) vsource dc=0.9 mag=0
RI0_1_3_4 (vs0_1_3_4 vi0_1_3_4) resistor r=50
VI1_1_3_4 (vs1_1_3_4 0) vsource dc=0.9 mag=0
RI1_1_3_4 (vs1_1_3_4 vi1_1_3_4) resistor r=50
VI2_1_3_4 (vs2_1_3_4 0) vsource dc=0.9 mag=0
RI2_1_3_4 (vs2_1_3_4 vi2_1_3_4) resistor r=50
VI3_1_3_4 (vs3_1_3_4 0) vsource dc=0.9 mag=0
RI3_1_3_4 (vs3_1_3_4 vi3_1_3_4) resistor r=50
VI4_1_3_4 (vs4_1_3_4 0) vsource dc=0.9 mag=1
RI4_1_3_4 (vs4_1_3_4 vi4_1_3_4) resistor r=50
VI5_1_3_4 (vs5_1_3_4 0) vsource dc=0.9 mag=0
RI5_1_3_4 (vs5_1_3_4 vi5_1_3_4) resistor r=50
VI6_1_3_4 (vs6_1_3_4 0) vsource dc=0.9 mag=0
RI6_1_3_4 (vs6_1_3_4 vi6_1_3_4) resistor r=50
VI7_1_3_4 (vs7_1_3_4 0) vsource dc=0.9 mag=0
RI7_1_3_4 (vs7_1_3_4 vi7_1_3_4) resistor r=50
X1_3_4 (vdd1_3_4 0 s2_1_3_4 s1_1_3_4 s0_1_3_4 vi7_1_3_4 vi6_1_3_4 vi5_1_3_4 vi4_1_3_4 vi3_1_3_4 vi2_1_3_4 vi1_1_3_4 vi0_1_3_4 vo1_3_4) input_mux_8to1
CL1_3_4 (vo1_3_4 0) capacitor c=1p
save vo1_3_4 VDD1_3_4:p
VDD1_3_5 (vdsrc1_3_5 0) vsource dc=1.8
RVD1_3_5 (vdsrc1_3_5 vdd1_3_5) resistor r=50
VS0_1_3_5 (ss0_1_3_5 0) vsource dc=1.8
RS0_1_3_5 (ss0_1_3_5 s0_1_3_5) resistor r=50
VS1_1_3_5 (ss1_1_3_5 0) vsource dc=1.8
RS1_1_3_5 (ss1_1_3_5 s1_1_3_5) resistor r=50
VS2_1_3_5 (ss2_1_3_5 0) vsource dc=0
RS2_1_3_5 (ss2_1_3_5 s2_1_3_5) resistor r=50
VI0_1_3_5 (vs0_1_3_5 0) vsource dc=0.9 mag=0
RI0_1_3_5 (vs0_1_3_5 vi0_1_3_5) resistor r=50
VI1_1_3_5 (vs1_1_3_5 0) vsource dc=0.9 mag=0
RI1_1_3_5 (vs1_1_3_5 vi1_1_3_5) resistor r=50
VI2_1_3_5 (vs2_1_3_5 0) vsource dc=0.9 mag=0
RI2_1_3_5 (vs2_1_3_5 vi2_1_3_5) resistor r=50
VI3_1_3_5 (vs3_1_3_5 0) vsource dc=0.9 mag=0
RI3_1_3_5 (vs3_1_3_5 vi3_1_3_5) resistor r=50
VI4_1_3_5 (vs4_1_3_5 0) vsource dc=0.9 mag=0
RI4_1_3_5 (vs4_1_3_5 vi4_1_3_5) resistor r=50
VI5_1_3_5 (vs5_1_3_5 0) vsource dc=0.9 mag=1
RI5_1_3_5 (vs5_1_3_5 vi5_1_3_5) resistor r=50
VI6_1_3_5 (vs6_1_3_5 0) vsource dc=0.9 mag=0
RI6_1_3_5 (vs6_1_3_5 vi6_1_3_5) resistor r=50
VI7_1_3_5 (vs7_1_3_5 0) vsource dc=0.9 mag=0
RI7_1_3_5 (vs7_1_3_5 vi7_1_3_5) resistor r=50
X1_3_5 (vdd1_3_5 0 s2_1_3_5 s1_1_3_5 s0_1_3_5 vi7_1_3_5 vi6_1_3_5 vi5_1_3_5 vi4_1_3_5 vi3_1_3_5 vi2_1_3_5 vi1_1_3_5 vi0_1_3_5 vo1_3_5) input_mux_8to1
CL1_3_5 (vo1_3_5 0) capacitor c=1p
save vo1_3_5 VDD1_3_5:p
VDD1_3_6 (vdsrc1_3_6 0) vsource dc=1.8
RVD1_3_6 (vdsrc1_3_6 vdd1_3_6) resistor r=50
VS0_1_3_6 (ss0_1_3_6 0) vsource dc=1.8
RS0_1_3_6 (ss0_1_3_6 s0_1_3_6) resistor r=50
VS1_1_3_6 (ss1_1_3_6 0) vsource dc=1.8
RS1_1_3_6 (ss1_1_3_6 s1_1_3_6) resistor r=50
VS2_1_3_6 (ss2_1_3_6 0) vsource dc=0
RS2_1_3_6 (ss2_1_3_6 s2_1_3_6) resistor r=50
VI0_1_3_6 (vs0_1_3_6 0) vsource dc=0.9 mag=0
RI0_1_3_6 (vs0_1_3_6 vi0_1_3_6) resistor r=50
VI1_1_3_6 (vs1_1_3_6 0) vsource dc=0.9 mag=0
RI1_1_3_6 (vs1_1_3_6 vi1_1_3_6) resistor r=50
VI2_1_3_6 (vs2_1_3_6 0) vsource dc=0.9 mag=0
RI2_1_3_6 (vs2_1_3_6 vi2_1_3_6) resistor r=50
VI3_1_3_6 (vs3_1_3_6 0) vsource dc=0.9 mag=0
RI3_1_3_6 (vs3_1_3_6 vi3_1_3_6) resistor r=50
VI4_1_3_6 (vs4_1_3_6 0) vsource dc=0.9 mag=0
RI4_1_3_6 (vs4_1_3_6 vi4_1_3_6) resistor r=50
VI5_1_3_6 (vs5_1_3_6 0) vsource dc=0.9 mag=0
RI5_1_3_6 (vs5_1_3_6 vi5_1_3_6) resistor r=50
VI6_1_3_6 (vs6_1_3_6 0) vsource dc=0.9 mag=1
RI6_1_3_6 (vs6_1_3_6 vi6_1_3_6) resistor r=50
VI7_1_3_6 (vs7_1_3_6 0) vsource dc=0.9 mag=0
RI7_1_3_6 (vs7_1_3_6 vi7_1_3_6) resistor r=50
X1_3_6 (vdd1_3_6 0 s2_1_3_6 s1_1_3_6 s0_1_3_6 vi7_1_3_6 vi6_1_3_6 vi5_1_3_6 vi4_1_3_6 vi3_1_3_6 vi2_1_3_6 vi1_1_3_6 vi0_1_3_6 vo1_3_6) input_mux_8to1
CL1_3_6 (vo1_3_6 0) capacitor c=1p
save vo1_3_6 VDD1_3_6:p
VDD1_3_7 (vdsrc1_3_7 0) vsource dc=1.8
RVD1_3_7 (vdsrc1_3_7 vdd1_3_7) resistor r=50
VS0_1_3_7 (ss0_1_3_7 0) vsource dc=1.8
RS0_1_3_7 (ss0_1_3_7 s0_1_3_7) resistor r=50
VS1_1_3_7 (ss1_1_3_7 0) vsource dc=1.8
RS1_1_3_7 (ss1_1_3_7 s1_1_3_7) resistor r=50
VS2_1_3_7 (ss2_1_3_7 0) vsource dc=0
RS2_1_3_7 (ss2_1_3_7 s2_1_3_7) resistor r=50
VI0_1_3_7 (vs0_1_3_7 0) vsource dc=0.9 mag=0
RI0_1_3_7 (vs0_1_3_7 vi0_1_3_7) resistor r=50
VI1_1_3_7 (vs1_1_3_7 0) vsource dc=0.9 mag=0
RI1_1_3_7 (vs1_1_3_7 vi1_1_3_7) resistor r=50
VI2_1_3_7 (vs2_1_3_7 0) vsource dc=0.9 mag=0
RI2_1_3_7 (vs2_1_3_7 vi2_1_3_7) resistor r=50
VI3_1_3_7 (vs3_1_3_7 0) vsource dc=0.9 mag=0
RI3_1_3_7 (vs3_1_3_7 vi3_1_3_7) resistor r=50
VI4_1_3_7 (vs4_1_3_7 0) vsource dc=0.9 mag=0
RI4_1_3_7 (vs4_1_3_7 vi4_1_3_7) resistor r=50
VI5_1_3_7 (vs5_1_3_7 0) vsource dc=0.9 mag=0
RI5_1_3_7 (vs5_1_3_7 vi5_1_3_7) resistor r=50
VI6_1_3_7 (vs6_1_3_7 0) vsource dc=0.9 mag=0
RI6_1_3_7 (vs6_1_3_7 vi6_1_3_7) resistor r=50
VI7_1_3_7 (vs7_1_3_7 0) vsource dc=0.9 mag=1
RI7_1_3_7 (vs7_1_3_7 vi7_1_3_7) resistor r=50
X1_3_7 (vdd1_3_7 0 s2_1_3_7 s1_1_3_7 s0_1_3_7 vi7_1_3_7 vi6_1_3_7 vi5_1_3_7 vi4_1_3_7 vi3_1_3_7 vi2_1_3_7 vi1_1_3_7 vi0_1_3_7 vo1_3_7) input_mux_8to1
CL1_3_7 (vo1_3_7 0) capacitor c=1p
save vo1_3_7 VDD1_3_7:p
VDD1_4_0 (vdsrc1_4_0 0) vsource dc=1.8
RVD1_4_0 (vdsrc1_4_0 vdd1_4_0) resistor r=50
VS0_1_4_0 (ss0_1_4_0 0) vsource dc=0
RS0_1_4_0 (ss0_1_4_0 s0_1_4_0) resistor r=50
VS1_1_4_0 (ss1_1_4_0 0) vsource dc=0
RS1_1_4_0 (ss1_1_4_0 s1_1_4_0) resistor r=50
VS2_1_4_0 (ss2_1_4_0 0) vsource dc=1.8
RS2_1_4_0 (ss2_1_4_0 s2_1_4_0) resistor r=50
VI0_1_4_0 (vs0_1_4_0 0) vsource dc=0.9 mag=1
RI0_1_4_0 (vs0_1_4_0 vi0_1_4_0) resistor r=50
VI1_1_4_0 (vs1_1_4_0 0) vsource dc=0.9 mag=0
RI1_1_4_0 (vs1_1_4_0 vi1_1_4_0) resistor r=50
VI2_1_4_0 (vs2_1_4_0 0) vsource dc=0.9 mag=0
RI2_1_4_0 (vs2_1_4_0 vi2_1_4_0) resistor r=50
VI3_1_4_0 (vs3_1_4_0 0) vsource dc=0.9 mag=0
RI3_1_4_0 (vs3_1_4_0 vi3_1_4_0) resistor r=50
VI4_1_4_0 (vs4_1_4_0 0) vsource dc=0.9 mag=0
RI4_1_4_0 (vs4_1_4_0 vi4_1_4_0) resistor r=50
VI5_1_4_0 (vs5_1_4_0 0) vsource dc=0.9 mag=0
RI5_1_4_0 (vs5_1_4_0 vi5_1_4_0) resistor r=50
VI6_1_4_0 (vs6_1_4_0 0) vsource dc=0.9 mag=0
RI6_1_4_0 (vs6_1_4_0 vi6_1_4_0) resistor r=50
VI7_1_4_0 (vs7_1_4_0 0) vsource dc=0.9 mag=0
RI7_1_4_0 (vs7_1_4_0 vi7_1_4_0) resistor r=50
X1_4_0 (vdd1_4_0 0 s2_1_4_0 s1_1_4_0 s0_1_4_0 vi7_1_4_0 vi6_1_4_0 vi5_1_4_0 vi4_1_4_0 vi3_1_4_0 vi2_1_4_0 vi1_1_4_0 vi0_1_4_0 vo1_4_0) input_mux_8to1
CL1_4_0 (vo1_4_0 0) capacitor c=1p
save vo1_4_0 VDD1_4_0:p
VDD1_4_1 (vdsrc1_4_1 0) vsource dc=1.8
RVD1_4_1 (vdsrc1_4_1 vdd1_4_1) resistor r=50
VS0_1_4_1 (ss0_1_4_1 0) vsource dc=0
RS0_1_4_1 (ss0_1_4_1 s0_1_4_1) resistor r=50
VS1_1_4_1 (ss1_1_4_1 0) vsource dc=0
RS1_1_4_1 (ss1_1_4_1 s1_1_4_1) resistor r=50
VS2_1_4_1 (ss2_1_4_1 0) vsource dc=1.8
RS2_1_4_1 (ss2_1_4_1 s2_1_4_1) resistor r=50
VI0_1_4_1 (vs0_1_4_1 0) vsource dc=0.9 mag=0
RI0_1_4_1 (vs0_1_4_1 vi0_1_4_1) resistor r=50
VI1_1_4_1 (vs1_1_4_1 0) vsource dc=0.9 mag=1
RI1_1_4_1 (vs1_1_4_1 vi1_1_4_1) resistor r=50
VI2_1_4_1 (vs2_1_4_1 0) vsource dc=0.9 mag=0
RI2_1_4_1 (vs2_1_4_1 vi2_1_4_1) resistor r=50
VI3_1_4_1 (vs3_1_4_1 0) vsource dc=0.9 mag=0
RI3_1_4_1 (vs3_1_4_1 vi3_1_4_1) resistor r=50
VI4_1_4_1 (vs4_1_4_1 0) vsource dc=0.9 mag=0
RI4_1_4_1 (vs4_1_4_1 vi4_1_4_1) resistor r=50
VI5_1_4_1 (vs5_1_4_1 0) vsource dc=0.9 mag=0
RI5_1_4_1 (vs5_1_4_1 vi5_1_4_1) resistor r=50
VI6_1_4_1 (vs6_1_4_1 0) vsource dc=0.9 mag=0
RI6_1_4_1 (vs6_1_4_1 vi6_1_4_1) resistor r=50
VI7_1_4_1 (vs7_1_4_1 0) vsource dc=0.9 mag=0
RI7_1_4_1 (vs7_1_4_1 vi7_1_4_1) resistor r=50
X1_4_1 (vdd1_4_1 0 s2_1_4_1 s1_1_4_1 s0_1_4_1 vi7_1_4_1 vi6_1_4_1 vi5_1_4_1 vi4_1_4_1 vi3_1_4_1 vi2_1_4_1 vi1_1_4_1 vi0_1_4_1 vo1_4_1) input_mux_8to1
CL1_4_1 (vo1_4_1 0) capacitor c=1p
save vo1_4_1 VDD1_4_1:p
VDD1_4_2 (vdsrc1_4_2 0) vsource dc=1.8
RVD1_4_2 (vdsrc1_4_2 vdd1_4_2) resistor r=50
VS0_1_4_2 (ss0_1_4_2 0) vsource dc=0
RS0_1_4_2 (ss0_1_4_2 s0_1_4_2) resistor r=50
VS1_1_4_2 (ss1_1_4_2 0) vsource dc=0
RS1_1_4_2 (ss1_1_4_2 s1_1_4_2) resistor r=50
VS2_1_4_2 (ss2_1_4_2 0) vsource dc=1.8
RS2_1_4_2 (ss2_1_4_2 s2_1_4_2) resistor r=50
VI0_1_4_2 (vs0_1_4_2 0) vsource dc=0.9 mag=0
RI0_1_4_2 (vs0_1_4_2 vi0_1_4_2) resistor r=50
VI1_1_4_2 (vs1_1_4_2 0) vsource dc=0.9 mag=0
RI1_1_4_2 (vs1_1_4_2 vi1_1_4_2) resistor r=50
VI2_1_4_2 (vs2_1_4_2 0) vsource dc=0.9 mag=1
RI2_1_4_2 (vs2_1_4_2 vi2_1_4_2) resistor r=50
VI3_1_4_2 (vs3_1_4_2 0) vsource dc=0.9 mag=0
RI3_1_4_2 (vs3_1_4_2 vi3_1_4_2) resistor r=50
VI4_1_4_2 (vs4_1_4_2 0) vsource dc=0.9 mag=0
RI4_1_4_2 (vs4_1_4_2 vi4_1_4_2) resistor r=50
VI5_1_4_2 (vs5_1_4_2 0) vsource dc=0.9 mag=0
RI5_1_4_2 (vs5_1_4_2 vi5_1_4_2) resistor r=50
VI6_1_4_2 (vs6_1_4_2 0) vsource dc=0.9 mag=0
RI6_1_4_2 (vs6_1_4_2 vi6_1_4_2) resistor r=50
VI7_1_4_2 (vs7_1_4_2 0) vsource dc=0.9 mag=0
RI7_1_4_2 (vs7_1_4_2 vi7_1_4_2) resistor r=50
X1_4_2 (vdd1_4_2 0 s2_1_4_2 s1_1_4_2 s0_1_4_2 vi7_1_4_2 vi6_1_4_2 vi5_1_4_2 vi4_1_4_2 vi3_1_4_2 vi2_1_4_2 vi1_1_4_2 vi0_1_4_2 vo1_4_2) input_mux_8to1
CL1_4_2 (vo1_4_2 0) capacitor c=1p
save vo1_4_2 VDD1_4_2:p
VDD1_4_3 (vdsrc1_4_3 0) vsource dc=1.8
RVD1_4_3 (vdsrc1_4_3 vdd1_4_3) resistor r=50
VS0_1_4_3 (ss0_1_4_3 0) vsource dc=0
RS0_1_4_3 (ss0_1_4_3 s0_1_4_3) resistor r=50
VS1_1_4_3 (ss1_1_4_3 0) vsource dc=0
RS1_1_4_3 (ss1_1_4_3 s1_1_4_3) resistor r=50
VS2_1_4_3 (ss2_1_4_3 0) vsource dc=1.8
RS2_1_4_3 (ss2_1_4_3 s2_1_4_3) resistor r=50
VI0_1_4_3 (vs0_1_4_3 0) vsource dc=0.9 mag=0
RI0_1_4_3 (vs0_1_4_3 vi0_1_4_3) resistor r=50
VI1_1_4_3 (vs1_1_4_3 0) vsource dc=0.9 mag=0
RI1_1_4_3 (vs1_1_4_3 vi1_1_4_3) resistor r=50
VI2_1_4_3 (vs2_1_4_3 0) vsource dc=0.9 mag=0
RI2_1_4_3 (vs2_1_4_3 vi2_1_4_3) resistor r=50
VI3_1_4_3 (vs3_1_4_3 0) vsource dc=0.9 mag=1
RI3_1_4_3 (vs3_1_4_3 vi3_1_4_3) resistor r=50
VI4_1_4_3 (vs4_1_4_3 0) vsource dc=0.9 mag=0
RI4_1_4_3 (vs4_1_4_3 vi4_1_4_3) resistor r=50
VI5_1_4_3 (vs5_1_4_3 0) vsource dc=0.9 mag=0
RI5_1_4_3 (vs5_1_4_3 vi5_1_4_3) resistor r=50
VI6_1_4_3 (vs6_1_4_3 0) vsource dc=0.9 mag=0
RI6_1_4_3 (vs6_1_4_3 vi6_1_4_3) resistor r=50
VI7_1_4_3 (vs7_1_4_3 0) vsource dc=0.9 mag=0
RI7_1_4_3 (vs7_1_4_3 vi7_1_4_3) resistor r=50
X1_4_3 (vdd1_4_3 0 s2_1_4_3 s1_1_4_3 s0_1_4_3 vi7_1_4_3 vi6_1_4_3 vi5_1_4_3 vi4_1_4_3 vi3_1_4_3 vi2_1_4_3 vi1_1_4_3 vi0_1_4_3 vo1_4_3) input_mux_8to1
CL1_4_3 (vo1_4_3 0) capacitor c=1p
save vo1_4_3 VDD1_4_3:p
VDD1_4_4 (vdsrc1_4_4 0) vsource dc=1.8
RVD1_4_4 (vdsrc1_4_4 vdd1_4_4) resistor r=50
VS0_1_4_4 (ss0_1_4_4 0) vsource dc=0
RS0_1_4_4 (ss0_1_4_4 s0_1_4_4) resistor r=50
VS1_1_4_4 (ss1_1_4_4 0) vsource dc=0
RS1_1_4_4 (ss1_1_4_4 s1_1_4_4) resistor r=50
VS2_1_4_4 (ss2_1_4_4 0) vsource dc=1.8
RS2_1_4_4 (ss2_1_4_4 s2_1_4_4) resistor r=50
VI0_1_4_4 (vs0_1_4_4 0) vsource dc=0.9 mag=0
RI0_1_4_4 (vs0_1_4_4 vi0_1_4_4) resistor r=50
VI1_1_4_4 (vs1_1_4_4 0) vsource dc=0.9 mag=0
RI1_1_4_4 (vs1_1_4_4 vi1_1_4_4) resistor r=50
VI2_1_4_4 (vs2_1_4_4 0) vsource dc=0.9 mag=0
RI2_1_4_4 (vs2_1_4_4 vi2_1_4_4) resistor r=50
VI3_1_4_4 (vs3_1_4_4 0) vsource dc=0.9 mag=0
RI3_1_4_4 (vs3_1_4_4 vi3_1_4_4) resistor r=50
VI4_1_4_4 (vs4_1_4_4 0) vsource dc=0.9 mag=1
RI4_1_4_4 (vs4_1_4_4 vi4_1_4_4) resistor r=50
VI5_1_4_4 (vs5_1_4_4 0) vsource dc=0.9 mag=0
RI5_1_4_4 (vs5_1_4_4 vi5_1_4_4) resistor r=50
VI6_1_4_4 (vs6_1_4_4 0) vsource dc=0.9 mag=0
RI6_1_4_4 (vs6_1_4_4 vi6_1_4_4) resistor r=50
VI7_1_4_4 (vs7_1_4_4 0) vsource dc=0.9 mag=0
RI7_1_4_4 (vs7_1_4_4 vi7_1_4_4) resistor r=50
X1_4_4 (vdd1_4_4 0 s2_1_4_4 s1_1_4_4 s0_1_4_4 vi7_1_4_4 vi6_1_4_4 vi5_1_4_4 vi4_1_4_4 vi3_1_4_4 vi2_1_4_4 vi1_1_4_4 vi0_1_4_4 vo1_4_4) input_mux_8to1
CL1_4_4 (vo1_4_4 0) capacitor c=1p
save vo1_4_4 VDD1_4_4:p
VDD1_4_5 (vdsrc1_4_5 0) vsource dc=1.8
RVD1_4_5 (vdsrc1_4_5 vdd1_4_5) resistor r=50
VS0_1_4_5 (ss0_1_4_5 0) vsource dc=0
RS0_1_4_5 (ss0_1_4_5 s0_1_4_5) resistor r=50
VS1_1_4_5 (ss1_1_4_5 0) vsource dc=0
RS1_1_4_5 (ss1_1_4_5 s1_1_4_5) resistor r=50
VS2_1_4_5 (ss2_1_4_5 0) vsource dc=1.8
RS2_1_4_5 (ss2_1_4_5 s2_1_4_5) resistor r=50
VI0_1_4_5 (vs0_1_4_5 0) vsource dc=0.9 mag=0
RI0_1_4_5 (vs0_1_4_5 vi0_1_4_5) resistor r=50
VI1_1_4_5 (vs1_1_4_5 0) vsource dc=0.9 mag=0
RI1_1_4_5 (vs1_1_4_5 vi1_1_4_5) resistor r=50
VI2_1_4_5 (vs2_1_4_5 0) vsource dc=0.9 mag=0
RI2_1_4_5 (vs2_1_4_5 vi2_1_4_5) resistor r=50
VI3_1_4_5 (vs3_1_4_5 0) vsource dc=0.9 mag=0
RI3_1_4_5 (vs3_1_4_5 vi3_1_4_5) resistor r=50
VI4_1_4_5 (vs4_1_4_5 0) vsource dc=0.9 mag=0
RI4_1_4_5 (vs4_1_4_5 vi4_1_4_5) resistor r=50
VI5_1_4_5 (vs5_1_4_5 0) vsource dc=0.9 mag=1
RI5_1_4_5 (vs5_1_4_5 vi5_1_4_5) resistor r=50
VI6_1_4_5 (vs6_1_4_5 0) vsource dc=0.9 mag=0
RI6_1_4_5 (vs6_1_4_5 vi6_1_4_5) resistor r=50
VI7_1_4_5 (vs7_1_4_5 0) vsource dc=0.9 mag=0
RI7_1_4_5 (vs7_1_4_5 vi7_1_4_5) resistor r=50
X1_4_5 (vdd1_4_5 0 s2_1_4_5 s1_1_4_5 s0_1_4_5 vi7_1_4_5 vi6_1_4_5 vi5_1_4_5 vi4_1_4_5 vi3_1_4_5 vi2_1_4_5 vi1_1_4_5 vi0_1_4_5 vo1_4_5) input_mux_8to1
CL1_4_5 (vo1_4_5 0) capacitor c=1p
save vo1_4_5 VDD1_4_5:p
VDD1_4_6 (vdsrc1_4_6 0) vsource dc=1.8
RVD1_4_6 (vdsrc1_4_6 vdd1_4_6) resistor r=50
VS0_1_4_6 (ss0_1_4_6 0) vsource dc=0
RS0_1_4_6 (ss0_1_4_6 s0_1_4_6) resistor r=50
VS1_1_4_6 (ss1_1_4_6 0) vsource dc=0
RS1_1_4_6 (ss1_1_4_6 s1_1_4_6) resistor r=50
VS2_1_4_6 (ss2_1_4_6 0) vsource dc=1.8
RS2_1_4_6 (ss2_1_4_6 s2_1_4_6) resistor r=50
VI0_1_4_6 (vs0_1_4_6 0) vsource dc=0.9 mag=0
RI0_1_4_6 (vs0_1_4_6 vi0_1_4_6) resistor r=50
VI1_1_4_6 (vs1_1_4_6 0) vsource dc=0.9 mag=0
RI1_1_4_6 (vs1_1_4_6 vi1_1_4_6) resistor r=50
VI2_1_4_6 (vs2_1_4_6 0) vsource dc=0.9 mag=0
RI2_1_4_6 (vs2_1_4_6 vi2_1_4_6) resistor r=50
VI3_1_4_6 (vs3_1_4_6 0) vsource dc=0.9 mag=0
RI3_1_4_6 (vs3_1_4_6 vi3_1_4_6) resistor r=50
VI4_1_4_6 (vs4_1_4_6 0) vsource dc=0.9 mag=0
RI4_1_4_6 (vs4_1_4_6 vi4_1_4_6) resistor r=50
VI5_1_4_6 (vs5_1_4_6 0) vsource dc=0.9 mag=0
RI5_1_4_6 (vs5_1_4_6 vi5_1_4_6) resistor r=50
VI6_1_4_6 (vs6_1_4_6 0) vsource dc=0.9 mag=1
RI6_1_4_6 (vs6_1_4_6 vi6_1_4_6) resistor r=50
VI7_1_4_6 (vs7_1_4_6 0) vsource dc=0.9 mag=0
RI7_1_4_6 (vs7_1_4_6 vi7_1_4_6) resistor r=50
X1_4_6 (vdd1_4_6 0 s2_1_4_6 s1_1_4_6 s0_1_4_6 vi7_1_4_6 vi6_1_4_6 vi5_1_4_6 vi4_1_4_6 vi3_1_4_6 vi2_1_4_6 vi1_1_4_6 vi0_1_4_6 vo1_4_6) input_mux_8to1
CL1_4_6 (vo1_4_6 0) capacitor c=1p
save vo1_4_6 VDD1_4_6:p
VDD1_4_7 (vdsrc1_4_7 0) vsource dc=1.8
RVD1_4_7 (vdsrc1_4_7 vdd1_4_7) resistor r=50
VS0_1_4_7 (ss0_1_4_7 0) vsource dc=0
RS0_1_4_7 (ss0_1_4_7 s0_1_4_7) resistor r=50
VS1_1_4_7 (ss1_1_4_7 0) vsource dc=0
RS1_1_4_7 (ss1_1_4_7 s1_1_4_7) resistor r=50
VS2_1_4_7 (ss2_1_4_7 0) vsource dc=1.8
RS2_1_4_7 (ss2_1_4_7 s2_1_4_7) resistor r=50
VI0_1_4_7 (vs0_1_4_7 0) vsource dc=0.9 mag=0
RI0_1_4_7 (vs0_1_4_7 vi0_1_4_7) resistor r=50
VI1_1_4_7 (vs1_1_4_7 0) vsource dc=0.9 mag=0
RI1_1_4_7 (vs1_1_4_7 vi1_1_4_7) resistor r=50
VI2_1_4_7 (vs2_1_4_7 0) vsource dc=0.9 mag=0
RI2_1_4_7 (vs2_1_4_7 vi2_1_4_7) resistor r=50
VI3_1_4_7 (vs3_1_4_7 0) vsource dc=0.9 mag=0
RI3_1_4_7 (vs3_1_4_7 vi3_1_4_7) resistor r=50
VI4_1_4_7 (vs4_1_4_7 0) vsource dc=0.9 mag=0
RI4_1_4_7 (vs4_1_4_7 vi4_1_4_7) resistor r=50
VI5_1_4_7 (vs5_1_4_7 0) vsource dc=0.9 mag=0
RI5_1_4_7 (vs5_1_4_7 vi5_1_4_7) resistor r=50
VI6_1_4_7 (vs6_1_4_7 0) vsource dc=0.9 mag=0
RI6_1_4_7 (vs6_1_4_7 vi6_1_4_7) resistor r=50
VI7_1_4_7 (vs7_1_4_7 0) vsource dc=0.9 mag=1
RI7_1_4_7 (vs7_1_4_7 vi7_1_4_7) resistor r=50
X1_4_7 (vdd1_4_7 0 s2_1_4_7 s1_1_4_7 s0_1_4_7 vi7_1_4_7 vi6_1_4_7 vi5_1_4_7 vi4_1_4_7 vi3_1_4_7 vi2_1_4_7 vi1_1_4_7 vi0_1_4_7 vo1_4_7) input_mux_8to1
CL1_4_7 (vo1_4_7 0) capacitor c=1p
save vo1_4_7 VDD1_4_7:p
VDD1_5_0 (vdsrc1_5_0 0) vsource dc=1.8
RVD1_5_0 (vdsrc1_5_0 vdd1_5_0) resistor r=50
VS0_1_5_0 (ss0_1_5_0 0) vsource dc=1.8
RS0_1_5_0 (ss0_1_5_0 s0_1_5_0) resistor r=50
VS1_1_5_0 (ss1_1_5_0 0) vsource dc=0
RS1_1_5_0 (ss1_1_5_0 s1_1_5_0) resistor r=50
VS2_1_5_0 (ss2_1_5_0 0) vsource dc=1.8
RS2_1_5_0 (ss2_1_5_0 s2_1_5_0) resistor r=50
VI0_1_5_0 (vs0_1_5_0 0) vsource dc=0.9 mag=1
RI0_1_5_0 (vs0_1_5_0 vi0_1_5_0) resistor r=50
VI1_1_5_0 (vs1_1_5_0 0) vsource dc=0.9 mag=0
RI1_1_5_0 (vs1_1_5_0 vi1_1_5_0) resistor r=50
VI2_1_5_0 (vs2_1_5_0 0) vsource dc=0.9 mag=0
RI2_1_5_0 (vs2_1_5_0 vi2_1_5_0) resistor r=50
VI3_1_5_0 (vs3_1_5_0 0) vsource dc=0.9 mag=0
RI3_1_5_0 (vs3_1_5_0 vi3_1_5_0) resistor r=50
VI4_1_5_0 (vs4_1_5_0 0) vsource dc=0.9 mag=0
RI4_1_5_0 (vs4_1_5_0 vi4_1_5_0) resistor r=50
VI5_1_5_0 (vs5_1_5_0 0) vsource dc=0.9 mag=0
RI5_1_5_0 (vs5_1_5_0 vi5_1_5_0) resistor r=50
VI6_1_5_0 (vs6_1_5_0 0) vsource dc=0.9 mag=0
RI6_1_5_0 (vs6_1_5_0 vi6_1_5_0) resistor r=50
VI7_1_5_0 (vs7_1_5_0 0) vsource dc=0.9 mag=0
RI7_1_5_0 (vs7_1_5_0 vi7_1_5_0) resistor r=50
X1_5_0 (vdd1_5_0 0 s2_1_5_0 s1_1_5_0 s0_1_5_0 vi7_1_5_0 vi6_1_5_0 vi5_1_5_0 vi4_1_5_0 vi3_1_5_0 vi2_1_5_0 vi1_1_5_0 vi0_1_5_0 vo1_5_0) input_mux_8to1
CL1_5_0 (vo1_5_0 0) capacitor c=1p
save vo1_5_0 VDD1_5_0:p
VDD1_5_1 (vdsrc1_5_1 0) vsource dc=1.8
RVD1_5_1 (vdsrc1_5_1 vdd1_5_1) resistor r=50
VS0_1_5_1 (ss0_1_5_1 0) vsource dc=1.8
RS0_1_5_1 (ss0_1_5_1 s0_1_5_1) resistor r=50
VS1_1_5_1 (ss1_1_5_1 0) vsource dc=0
RS1_1_5_1 (ss1_1_5_1 s1_1_5_1) resistor r=50
VS2_1_5_1 (ss2_1_5_1 0) vsource dc=1.8
RS2_1_5_1 (ss2_1_5_1 s2_1_5_1) resistor r=50
VI0_1_5_1 (vs0_1_5_1 0) vsource dc=0.9 mag=0
RI0_1_5_1 (vs0_1_5_1 vi0_1_5_1) resistor r=50
VI1_1_5_1 (vs1_1_5_1 0) vsource dc=0.9 mag=1
RI1_1_5_1 (vs1_1_5_1 vi1_1_5_1) resistor r=50
VI2_1_5_1 (vs2_1_5_1 0) vsource dc=0.9 mag=0
RI2_1_5_1 (vs2_1_5_1 vi2_1_5_1) resistor r=50
VI3_1_5_1 (vs3_1_5_1 0) vsource dc=0.9 mag=0
RI3_1_5_1 (vs3_1_5_1 vi3_1_5_1) resistor r=50
VI4_1_5_1 (vs4_1_5_1 0) vsource dc=0.9 mag=0
RI4_1_5_1 (vs4_1_5_1 vi4_1_5_1) resistor r=50
VI5_1_5_1 (vs5_1_5_1 0) vsource dc=0.9 mag=0
RI5_1_5_1 (vs5_1_5_1 vi5_1_5_1) resistor r=50
VI6_1_5_1 (vs6_1_5_1 0) vsource dc=0.9 mag=0
RI6_1_5_1 (vs6_1_5_1 vi6_1_5_1) resistor r=50
VI7_1_5_1 (vs7_1_5_1 0) vsource dc=0.9 mag=0
RI7_1_5_1 (vs7_1_5_1 vi7_1_5_1) resistor r=50
X1_5_1 (vdd1_5_1 0 s2_1_5_1 s1_1_5_1 s0_1_5_1 vi7_1_5_1 vi6_1_5_1 vi5_1_5_1 vi4_1_5_1 vi3_1_5_1 vi2_1_5_1 vi1_1_5_1 vi0_1_5_1 vo1_5_1) input_mux_8to1
CL1_5_1 (vo1_5_1 0) capacitor c=1p
save vo1_5_1 VDD1_5_1:p
VDD1_5_2 (vdsrc1_5_2 0) vsource dc=1.8
RVD1_5_2 (vdsrc1_5_2 vdd1_5_2) resistor r=50
VS0_1_5_2 (ss0_1_5_2 0) vsource dc=1.8
RS0_1_5_2 (ss0_1_5_2 s0_1_5_2) resistor r=50
VS1_1_5_2 (ss1_1_5_2 0) vsource dc=0
RS1_1_5_2 (ss1_1_5_2 s1_1_5_2) resistor r=50
VS2_1_5_2 (ss2_1_5_2 0) vsource dc=1.8
RS2_1_5_2 (ss2_1_5_2 s2_1_5_2) resistor r=50
VI0_1_5_2 (vs0_1_5_2 0) vsource dc=0.9 mag=0
RI0_1_5_2 (vs0_1_5_2 vi0_1_5_2) resistor r=50
VI1_1_5_2 (vs1_1_5_2 0) vsource dc=0.9 mag=0
RI1_1_5_2 (vs1_1_5_2 vi1_1_5_2) resistor r=50
VI2_1_5_2 (vs2_1_5_2 0) vsource dc=0.9 mag=1
RI2_1_5_2 (vs2_1_5_2 vi2_1_5_2) resistor r=50
VI3_1_5_2 (vs3_1_5_2 0) vsource dc=0.9 mag=0
RI3_1_5_2 (vs3_1_5_2 vi3_1_5_2) resistor r=50
VI4_1_5_2 (vs4_1_5_2 0) vsource dc=0.9 mag=0
RI4_1_5_2 (vs4_1_5_2 vi4_1_5_2) resistor r=50
VI5_1_5_2 (vs5_1_5_2 0) vsource dc=0.9 mag=0
RI5_1_5_2 (vs5_1_5_2 vi5_1_5_2) resistor r=50
VI6_1_5_2 (vs6_1_5_2 0) vsource dc=0.9 mag=0
RI6_1_5_2 (vs6_1_5_2 vi6_1_5_2) resistor r=50
VI7_1_5_2 (vs7_1_5_2 0) vsource dc=0.9 mag=0
RI7_1_5_2 (vs7_1_5_2 vi7_1_5_2) resistor r=50
X1_5_2 (vdd1_5_2 0 s2_1_5_2 s1_1_5_2 s0_1_5_2 vi7_1_5_2 vi6_1_5_2 vi5_1_5_2 vi4_1_5_2 vi3_1_5_2 vi2_1_5_2 vi1_1_5_2 vi0_1_5_2 vo1_5_2) input_mux_8to1
CL1_5_2 (vo1_5_2 0) capacitor c=1p
save vo1_5_2 VDD1_5_2:p
VDD1_5_3 (vdsrc1_5_3 0) vsource dc=1.8
RVD1_5_3 (vdsrc1_5_3 vdd1_5_3) resistor r=50
VS0_1_5_3 (ss0_1_5_3 0) vsource dc=1.8
RS0_1_5_3 (ss0_1_5_3 s0_1_5_3) resistor r=50
VS1_1_5_3 (ss1_1_5_3 0) vsource dc=0
RS1_1_5_3 (ss1_1_5_3 s1_1_5_3) resistor r=50
VS2_1_5_3 (ss2_1_5_3 0) vsource dc=1.8
RS2_1_5_3 (ss2_1_5_3 s2_1_5_3) resistor r=50
VI0_1_5_3 (vs0_1_5_3 0) vsource dc=0.9 mag=0
RI0_1_5_3 (vs0_1_5_3 vi0_1_5_3) resistor r=50
VI1_1_5_3 (vs1_1_5_3 0) vsource dc=0.9 mag=0
RI1_1_5_3 (vs1_1_5_3 vi1_1_5_3) resistor r=50
VI2_1_5_3 (vs2_1_5_3 0) vsource dc=0.9 mag=0
RI2_1_5_3 (vs2_1_5_3 vi2_1_5_3) resistor r=50
VI3_1_5_3 (vs3_1_5_3 0) vsource dc=0.9 mag=1
RI3_1_5_3 (vs3_1_5_3 vi3_1_5_3) resistor r=50
VI4_1_5_3 (vs4_1_5_3 0) vsource dc=0.9 mag=0
RI4_1_5_3 (vs4_1_5_3 vi4_1_5_3) resistor r=50
VI5_1_5_3 (vs5_1_5_3 0) vsource dc=0.9 mag=0
RI5_1_5_3 (vs5_1_5_3 vi5_1_5_3) resistor r=50
VI6_1_5_3 (vs6_1_5_3 0) vsource dc=0.9 mag=0
RI6_1_5_3 (vs6_1_5_3 vi6_1_5_3) resistor r=50
VI7_1_5_3 (vs7_1_5_3 0) vsource dc=0.9 mag=0
RI7_1_5_3 (vs7_1_5_3 vi7_1_5_3) resistor r=50
X1_5_3 (vdd1_5_3 0 s2_1_5_3 s1_1_5_3 s0_1_5_3 vi7_1_5_3 vi6_1_5_3 vi5_1_5_3 vi4_1_5_3 vi3_1_5_3 vi2_1_5_3 vi1_1_5_3 vi0_1_5_3 vo1_5_3) input_mux_8to1
CL1_5_3 (vo1_5_3 0) capacitor c=1p
save vo1_5_3 VDD1_5_3:p
VDD1_5_4 (vdsrc1_5_4 0) vsource dc=1.8
RVD1_5_4 (vdsrc1_5_4 vdd1_5_4) resistor r=50
VS0_1_5_4 (ss0_1_5_4 0) vsource dc=1.8
RS0_1_5_4 (ss0_1_5_4 s0_1_5_4) resistor r=50
VS1_1_5_4 (ss1_1_5_4 0) vsource dc=0
RS1_1_5_4 (ss1_1_5_4 s1_1_5_4) resistor r=50
VS2_1_5_4 (ss2_1_5_4 0) vsource dc=1.8
RS2_1_5_4 (ss2_1_5_4 s2_1_5_4) resistor r=50
VI0_1_5_4 (vs0_1_5_4 0) vsource dc=0.9 mag=0
RI0_1_5_4 (vs0_1_5_4 vi0_1_5_4) resistor r=50
VI1_1_5_4 (vs1_1_5_4 0) vsource dc=0.9 mag=0
RI1_1_5_4 (vs1_1_5_4 vi1_1_5_4) resistor r=50
VI2_1_5_4 (vs2_1_5_4 0) vsource dc=0.9 mag=0
RI2_1_5_4 (vs2_1_5_4 vi2_1_5_4) resistor r=50
VI3_1_5_4 (vs3_1_5_4 0) vsource dc=0.9 mag=0
RI3_1_5_4 (vs3_1_5_4 vi3_1_5_4) resistor r=50
VI4_1_5_4 (vs4_1_5_4 0) vsource dc=0.9 mag=1
RI4_1_5_4 (vs4_1_5_4 vi4_1_5_4) resistor r=50
VI5_1_5_4 (vs5_1_5_4 0) vsource dc=0.9 mag=0
RI5_1_5_4 (vs5_1_5_4 vi5_1_5_4) resistor r=50
VI6_1_5_4 (vs6_1_5_4 0) vsource dc=0.9 mag=0
RI6_1_5_4 (vs6_1_5_4 vi6_1_5_4) resistor r=50
VI7_1_5_4 (vs7_1_5_4 0) vsource dc=0.9 mag=0
RI7_1_5_4 (vs7_1_5_4 vi7_1_5_4) resistor r=50
X1_5_4 (vdd1_5_4 0 s2_1_5_4 s1_1_5_4 s0_1_5_4 vi7_1_5_4 vi6_1_5_4 vi5_1_5_4 vi4_1_5_4 vi3_1_5_4 vi2_1_5_4 vi1_1_5_4 vi0_1_5_4 vo1_5_4) input_mux_8to1
CL1_5_4 (vo1_5_4 0) capacitor c=1p
save vo1_5_4 VDD1_5_4:p
VDD1_5_5 (vdsrc1_5_5 0) vsource dc=1.8
RVD1_5_5 (vdsrc1_5_5 vdd1_5_5) resistor r=50
VS0_1_5_5 (ss0_1_5_5 0) vsource dc=1.8
RS0_1_5_5 (ss0_1_5_5 s0_1_5_5) resistor r=50
VS1_1_5_5 (ss1_1_5_5 0) vsource dc=0
RS1_1_5_5 (ss1_1_5_5 s1_1_5_5) resistor r=50
VS2_1_5_5 (ss2_1_5_5 0) vsource dc=1.8
RS2_1_5_5 (ss2_1_5_5 s2_1_5_5) resistor r=50
VI0_1_5_5 (vs0_1_5_5 0) vsource dc=0.9 mag=0
RI0_1_5_5 (vs0_1_5_5 vi0_1_5_5) resistor r=50
VI1_1_5_5 (vs1_1_5_5 0) vsource dc=0.9 mag=0
RI1_1_5_5 (vs1_1_5_5 vi1_1_5_5) resistor r=50
VI2_1_5_5 (vs2_1_5_5 0) vsource dc=0.9 mag=0
RI2_1_5_5 (vs2_1_5_5 vi2_1_5_5) resistor r=50
VI3_1_5_5 (vs3_1_5_5 0) vsource dc=0.9 mag=0
RI3_1_5_5 (vs3_1_5_5 vi3_1_5_5) resistor r=50
VI4_1_5_5 (vs4_1_5_5 0) vsource dc=0.9 mag=0
RI4_1_5_5 (vs4_1_5_5 vi4_1_5_5) resistor r=50
VI5_1_5_5 (vs5_1_5_5 0) vsource dc=0.9 mag=1
RI5_1_5_5 (vs5_1_5_5 vi5_1_5_5) resistor r=50
VI6_1_5_5 (vs6_1_5_5 0) vsource dc=0.9 mag=0
RI6_1_5_5 (vs6_1_5_5 vi6_1_5_5) resistor r=50
VI7_1_5_5 (vs7_1_5_5 0) vsource dc=0.9 mag=0
RI7_1_5_5 (vs7_1_5_5 vi7_1_5_5) resistor r=50
X1_5_5 (vdd1_5_5 0 s2_1_5_5 s1_1_5_5 s0_1_5_5 vi7_1_5_5 vi6_1_5_5 vi5_1_5_5 vi4_1_5_5 vi3_1_5_5 vi2_1_5_5 vi1_1_5_5 vi0_1_5_5 vo1_5_5) input_mux_8to1
CL1_5_5 (vo1_5_5 0) capacitor c=1p
save vo1_5_5 VDD1_5_5:p
VDD1_5_6 (vdsrc1_5_6 0) vsource dc=1.8
RVD1_5_6 (vdsrc1_5_6 vdd1_5_6) resistor r=50
VS0_1_5_6 (ss0_1_5_6 0) vsource dc=1.8
RS0_1_5_6 (ss0_1_5_6 s0_1_5_6) resistor r=50
VS1_1_5_6 (ss1_1_5_6 0) vsource dc=0
RS1_1_5_6 (ss1_1_5_6 s1_1_5_6) resistor r=50
VS2_1_5_6 (ss2_1_5_6 0) vsource dc=1.8
RS2_1_5_6 (ss2_1_5_6 s2_1_5_6) resistor r=50
VI0_1_5_6 (vs0_1_5_6 0) vsource dc=0.9 mag=0
RI0_1_5_6 (vs0_1_5_6 vi0_1_5_6) resistor r=50
VI1_1_5_6 (vs1_1_5_6 0) vsource dc=0.9 mag=0
RI1_1_5_6 (vs1_1_5_6 vi1_1_5_6) resistor r=50
VI2_1_5_6 (vs2_1_5_6 0) vsource dc=0.9 mag=0
RI2_1_5_6 (vs2_1_5_6 vi2_1_5_6) resistor r=50
VI3_1_5_6 (vs3_1_5_6 0) vsource dc=0.9 mag=0
RI3_1_5_6 (vs3_1_5_6 vi3_1_5_6) resistor r=50
VI4_1_5_6 (vs4_1_5_6 0) vsource dc=0.9 mag=0
RI4_1_5_6 (vs4_1_5_6 vi4_1_5_6) resistor r=50
VI5_1_5_6 (vs5_1_5_6 0) vsource dc=0.9 mag=0
RI5_1_5_6 (vs5_1_5_6 vi5_1_5_6) resistor r=50
VI6_1_5_6 (vs6_1_5_6 0) vsource dc=0.9 mag=1
RI6_1_5_6 (vs6_1_5_6 vi6_1_5_6) resistor r=50
VI7_1_5_6 (vs7_1_5_6 0) vsource dc=0.9 mag=0
RI7_1_5_6 (vs7_1_5_6 vi7_1_5_6) resistor r=50
X1_5_6 (vdd1_5_6 0 s2_1_5_6 s1_1_5_6 s0_1_5_6 vi7_1_5_6 vi6_1_5_6 vi5_1_5_6 vi4_1_5_6 vi3_1_5_6 vi2_1_5_6 vi1_1_5_6 vi0_1_5_6 vo1_5_6) input_mux_8to1
CL1_5_6 (vo1_5_6 0) capacitor c=1p
save vo1_5_6 VDD1_5_6:p
VDD1_5_7 (vdsrc1_5_7 0) vsource dc=1.8
RVD1_5_7 (vdsrc1_5_7 vdd1_5_7) resistor r=50
VS0_1_5_7 (ss0_1_5_7 0) vsource dc=1.8
RS0_1_5_7 (ss0_1_5_7 s0_1_5_7) resistor r=50
VS1_1_5_7 (ss1_1_5_7 0) vsource dc=0
RS1_1_5_7 (ss1_1_5_7 s1_1_5_7) resistor r=50
VS2_1_5_7 (ss2_1_5_7 0) vsource dc=1.8
RS2_1_5_7 (ss2_1_5_7 s2_1_5_7) resistor r=50
VI0_1_5_7 (vs0_1_5_7 0) vsource dc=0.9 mag=0
RI0_1_5_7 (vs0_1_5_7 vi0_1_5_7) resistor r=50
VI1_1_5_7 (vs1_1_5_7 0) vsource dc=0.9 mag=0
RI1_1_5_7 (vs1_1_5_7 vi1_1_5_7) resistor r=50
VI2_1_5_7 (vs2_1_5_7 0) vsource dc=0.9 mag=0
RI2_1_5_7 (vs2_1_5_7 vi2_1_5_7) resistor r=50
VI3_1_5_7 (vs3_1_5_7 0) vsource dc=0.9 mag=0
RI3_1_5_7 (vs3_1_5_7 vi3_1_5_7) resistor r=50
VI4_1_5_7 (vs4_1_5_7 0) vsource dc=0.9 mag=0
RI4_1_5_7 (vs4_1_5_7 vi4_1_5_7) resistor r=50
VI5_1_5_7 (vs5_1_5_7 0) vsource dc=0.9 mag=0
RI5_1_5_7 (vs5_1_5_7 vi5_1_5_7) resistor r=50
VI6_1_5_7 (vs6_1_5_7 0) vsource dc=0.9 mag=0
RI6_1_5_7 (vs6_1_5_7 vi6_1_5_7) resistor r=50
VI7_1_5_7 (vs7_1_5_7 0) vsource dc=0.9 mag=1
RI7_1_5_7 (vs7_1_5_7 vi7_1_5_7) resistor r=50
X1_5_7 (vdd1_5_7 0 s2_1_5_7 s1_1_5_7 s0_1_5_7 vi7_1_5_7 vi6_1_5_7 vi5_1_5_7 vi4_1_5_7 vi3_1_5_7 vi2_1_5_7 vi1_1_5_7 vi0_1_5_7 vo1_5_7) input_mux_8to1
CL1_5_7 (vo1_5_7 0) capacitor c=1p
save vo1_5_7 VDD1_5_7:p
VDD1_6_0 (vdsrc1_6_0 0) vsource dc=1.8
RVD1_6_0 (vdsrc1_6_0 vdd1_6_0) resistor r=50
VS0_1_6_0 (ss0_1_6_0 0) vsource dc=0
RS0_1_6_0 (ss0_1_6_0 s0_1_6_0) resistor r=50
VS1_1_6_0 (ss1_1_6_0 0) vsource dc=1.8
RS1_1_6_0 (ss1_1_6_0 s1_1_6_0) resistor r=50
VS2_1_6_0 (ss2_1_6_0 0) vsource dc=1.8
RS2_1_6_0 (ss2_1_6_0 s2_1_6_0) resistor r=50
VI0_1_6_0 (vs0_1_6_0 0) vsource dc=0.9 mag=1
RI0_1_6_0 (vs0_1_6_0 vi0_1_6_0) resistor r=50
VI1_1_6_0 (vs1_1_6_0 0) vsource dc=0.9 mag=0
RI1_1_6_0 (vs1_1_6_0 vi1_1_6_0) resistor r=50
VI2_1_6_0 (vs2_1_6_0 0) vsource dc=0.9 mag=0
RI2_1_6_0 (vs2_1_6_0 vi2_1_6_0) resistor r=50
VI3_1_6_0 (vs3_1_6_0 0) vsource dc=0.9 mag=0
RI3_1_6_0 (vs3_1_6_0 vi3_1_6_0) resistor r=50
VI4_1_6_0 (vs4_1_6_0 0) vsource dc=0.9 mag=0
RI4_1_6_0 (vs4_1_6_0 vi4_1_6_0) resistor r=50
VI5_1_6_0 (vs5_1_6_0 0) vsource dc=0.9 mag=0
RI5_1_6_0 (vs5_1_6_0 vi5_1_6_0) resistor r=50
VI6_1_6_0 (vs6_1_6_0 0) vsource dc=0.9 mag=0
RI6_1_6_0 (vs6_1_6_0 vi6_1_6_0) resistor r=50
VI7_1_6_0 (vs7_1_6_0 0) vsource dc=0.9 mag=0
RI7_1_6_0 (vs7_1_6_0 vi7_1_6_0) resistor r=50
X1_6_0 (vdd1_6_0 0 s2_1_6_0 s1_1_6_0 s0_1_6_0 vi7_1_6_0 vi6_1_6_0 vi5_1_6_0 vi4_1_6_0 vi3_1_6_0 vi2_1_6_0 vi1_1_6_0 vi0_1_6_0 vo1_6_0) input_mux_8to1
CL1_6_0 (vo1_6_0 0) capacitor c=1p
save vo1_6_0 VDD1_6_0:p
VDD1_6_1 (vdsrc1_6_1 0) vsource dc=1.8
RVD1_6_1 (vdsrc1_6_1 vdd1_6_1) resistor r=50
VS0_1_6_1 (ss0_1_6_1 0) vsource dc=0
RS0_1_6_1 (ss0_1_6_1 s0_1_6_1) resistor r=50
VS1_1_6_1 (ss1_1_6_1 0) vsource dc=1.8
RS1_1_6_1 (ss1_1_6_1 s1_1_6_1) resistor r=50
VS2_1_6_1 (ss2_1_6_1 0) vsource dc=1.8
RS2_1_6_1 (ss2_1_6_1 s2_1_6_1) resistor r=50
VI0_1_6_1 (vs0_1_6_1 0) vsource dc=0.9 mag=0
RI0_1_6_1 (vs0_1_6_1 vi0_1_6_1) resistor r=50
VI1_1_6_1 (vs1_1_6_1 0) vsource dc=0.9 mag=1
RI1_1_6_1 (vs1_1_6_1 vi1_1_6_1) resistor r=50
VI2_1_6_1 (vs2_1_6_1 0) vsource dc=0.9 mag=0
RI2_1_6_1 (vs2_1_6_1 vi2_1_6_1) resistor r=50
VI3_1_6_1 (vs3_1_6_1 0) vsource dc=0.9 mag=0
RI3_1_6_1 (vs3_1_6_1 vi3_1_6_1) resistor r=50
VI4_1_6_1 (vs4_1_6_1 0) vsource dc=0.9 mag=0
RI4_1_6_1 (vs4_1_6_1 vi4_1_6_1) resistor r=50
VI5_1_6_1 (vs5_1_6_1 0) vsource dc=0.9 mag=0
RI5_1_6_1 (vs5_1_6_1 vi5_1_6_1) resistor r=50
VI6_1_6_1 (vs6_1_6_1 0) vsource dc=0.9 mag=0
RI6_1_6_1 (vs6_1_6_1 vi6_1_6_1) resistor r=50
VI7_1_6_1 (vs7_1_6_1 0) vsource dc=0.9 mag=0
RI7_1_6_1 (vs7_1_6_1 vi7_1_6_1) resistor r=50
X1_6_1 (vdd1_6_1 0 s2_1_6_1 s1_1_6_1 s0_1_6_1 vi7_1_6_1 vi6_1_6_1 vi5_1_6_1 vi4_1_6_1 vi3_1_6_1 vi2_1_6_1 vi1_1_6_1 vi0_1_6_1 vo1_6_1) input_mux_8to1
CL1_6_1 (vo1_6_1 0) capacitor c=1p
save vo1_6_1 VDD1_6_1:p
VDD1_6_2 (vdsrc1_6_2 0) vsource dc=1.8
RVD1_6_2 (vdsrc1_6_2 vdd1_6_2) resistor r=50
VS0_1_6_2 (ss0_1_6_2 0) vsource dc=0
RS0_1_6_2 (ss0_1_6_2 s0_1_6_2) resistor r=50
VS1_1_6_2 (ss1_1_6_2 0) vsource dc=1.8
RS1_1_6_2 (ss1_1_6_2 s1_1_6_2) resistor r=50
VS2_1_6_2 (ss2_1_6_2 0) vsource dc=1.8
RS2_1_6_2 (ss2_1_6_2 s2_1_6_2) resistor r=50
VI0_1_6_2 (vs0_1_6_2 0) vsource dc=0.9 mag=0
RI0_1_6_2 (vs0_1_6_2 vi0_1_6_2) resistor r=50
VI1_1_6_2 (vs1_1_6_2 0) vsource dc=0.9 mag=0
RI1_1_6_2 (vs1_1_6_2 vi1_1_6_2) resistor r=50
VI2_1_6_2 (vs2_1_6_2 0) vsource dc=0.9 mag=1
RI2_1_6_2 (vs2_1_6_2 vi2_1_6_2) resistor r=50
VI3_1_6_2 (vs3_1_6_2 0) vsource dc=0.9 mag=0
RI3_1_6_2 (vs3_1_6_2 vi3_1_6_2) resistor r=50
VI4_1_6_2 (vs4_1_6_2 0) vsource dc=0.9 mag=0
RI4_1_6_2 (vs4_1_6_2 vi4_1_6_2) resistor r=50
VI5_1_6_2 (vs5_1_6_2 0) vsource dc=0.9 mag=0
RI5_1_6_2 (vs5_1_6_2 vi5_1_6_2) resistor r=50
VI6_1_6_2 (vs6_1_6_2 0) vsource dc=0.9 mag=0
RI6_1_6_2 (vs6_1_6_2 vi6_1_6_2) resistor r=50
VI7_1_6_2 (vs7_1_6_2 0) vsource dc=0.9 mag=0
RI7_1_6_2 (vs7_1_6_2 vi7_1_6_2) resistor r=50
X1_6_2 (vdd1_6_2 0 s2_1_6_2 s1_1_6_2 s0_1_6_2 vi7_1_6_2 vi6_1_6_2 vi5_1_6_2 vi4_1_6_2 vi3_1_6_2 vi2_1_6_2 vi1_1_6_2 vi0_1_6_2 vo1_6_2) input_mux_8to1
CL1_6_2 (vo1_6_2 0) capacitor c=1p
save vo1_6_2 VDD1_6_2:p
VDD1_6_3 (vdsrc1_6_3 0) vsource dc=1.8
RVD1_6_3 (vdsrc1_6_3 vdd1_6_3) resistor r=50
VS0_1_6_3 (ss0_1_6_3 0) vsource dc=0
RS0_1_6_3 (ss0_1_6_3 s0_1_6_3) resistor r=50
VS1_1_6_3 (ss1_1_6_3 0) vsource dc=1.8
RS1_1_6_3 (ss1_1_6_3 s1_1_6_3) resistor r=50
VS2_1_6_3 (ss2_1_6_3 0) vsource dc=1.8
RS2_1_6_3 (ss2_1_6_3 s2_1_6_3) resistor r=50
VI0_1_6_3 (vs0_1_6_3 0) vsource dc=0.9 mag=0
RI0_1_6_3 (vs0_1_6_3 vi0_1_6_3) resistor r=50
VI1_1_6_3 (vs1_1_6_3 0) vsource dc=0.9 mag=0
RI1_1_6_3 (vs1_1_6_3 vi1_1_6_3) resistor r=50
VI2_1_6_3 (vs2_1_6_3 0) vsource dc=0.9 mag=0
RI2_1_6_3 (vs2_1_6_3 vi2_1_6_3) resistor r=50
VI3_1_6_3 (vs3_1_6_3 0) vsource dc=0.9 mag=1
RI3_1_6_3 (vs3_1_6_3 vi3_1_6_3) resistor r=50
VI4_1_6_3 (vs4_1_6_3 0) vsource dc=0.9 mag=0
RI4_1_6_3 (vs4_1_6_3 vi4_1_6_3) resistor r=50
VI5_1_6_3 (vs5_1_6_3 0) vsource dc=0.9 mag=0
RI5_1_6_3 (vs5_1_6_3 vi5_1_6_3) resistor r=50
VI6_1_6_3 (vs6_1_6_3 0) vsource dc=0.9 mag=0
RI6_1_6_3 (vs6_1_6_3 vi6_1_6_3) resistor r=50
VI7_1_6_3 (vs7_1_6_3 0) vsource dc=0.9 mag=0
RI7_1_6_3 (vs7_1_6_3 vi7_1_6_3) resistor r=50
X1_6_3 (vdd1_6_3 0 s2_1_6_3 s1_1_6_3 s0_1_6_3 vi7_1_6_3 vi6_1_6_3 vi5_1_6_3 vi4_1_6_3 vi3_1_6_3 vi2_1_6_3 vi1_1_6_3 vi0_1_6_3 vo1_6_3) input_mux_8to1
CL1_6_3 (vo1_6_3 0) capacitor c=1p
save vo1_6_3 VDD1_6_3:p
VDD1_6_4 (vdsrc1_6_4 0) vsource dc=1.8
RVD1_6_4 (vdsrc1_6_4 vdd1_6_4) resistor r=50
VS0_1_6_4 (ss0_1_6_4 0) vsource dc=0
RS0_1_6_4 (ss0_1_6_4 s0_1_6_4) resistor r=50
VS1_1_6_4 (ss1_1_6_4 0) vsource dc=1.8
RS1_1_6_4 (ss1_1_6_4 s1_1_6_4) resistor r=50
VS2_1_6_4 (ss2_1_6_4 0) vsource dc=1.8
RS2_1_6_4 (ss2_1_6_4 s2_1_6_4) resistor r=50
VI0_1_6_4 (vs0_1_6_4 0) vsource dc=0.9 mag=0
RI0_1_6_4 (vs0_1_6_4 vi0_1_6_4) resistor r=50
VI1_1_6_4 (vs1_1_6_4 0) vsource dc=0.9 mag=0
RI1_1_6_4 (vs1_1_6_4 vi1_1_6_4) resistor r=50
VI2_1_6_4 (vs2_1_6_4 0) vsource dc=0.9 mag=0
RI2_1_6_4 (vs2_1_6_4 vi2_1_6_4) resistor r=50
VI3_1_6_4 (vs3_1_6_4 0) vsource dc=0.9 mag=0
RI3_1_6_4 (vs3_1_6_4 vi3_1_6_4) resistor r=50
VI4_1_6_4 (vs4_1_6_4 0) vsource dc=0.9 mag=1
RI4_1_6_4 (vs4_1_6_4 vi4_1_6_4) resistor r=50
VI5_1_6_4 (vs5_1_6_4 0) vsource dc=0.9 mag=0
RI5_1_6_4 (vs5_1_6_4 vi5_1_6_4) resistor r=50
VI6_1_6_4 (vs6_1_6_4 0) vsource dc=0.9 mag=0
RI6_1_6_4 (vs6_1_6_4 vi6_1_6_4) resistor r=50
VI7_1_6_4 (vs7_1_6_4 0) vsource dc=0.9 mag=0
RI7_1_6_4 (vs7_1_6_4 vi7_1_6_4) resistor r=50
X1_6_4 (vdd1_6_4 0 s2_1_6_4 s1_1_6_4 s0_1_6_4 vi7_1_6_4 vi6_1_6_4 vi5_1_6_4 vi4_1_6_4 vi3_1_6_4 vi2_1_6_4 vi1_1_6_4 vi0_1_6_4 vo1_6_4) input_mux_8to1
CL1_6_4 (vo1_6_4 0) capacitor c=1p
save vo1_6_4 VDD1_6_4:p
VDD1_6_5 (vdsrc1_6_5 0) vsource dc=1.8
RVD1_6_5 (vdsrc1_6_5 vdd1_6_5) resistor r=50
VS0_1_6_5 (ss0_1_6_5 0) vsource dc=0
RS0_1_6_5 (ss0_1_6_5 s0_1_6_5) resistor r=50
VS1_1_6_5 (ss1_1_6_5 0) vsource dc=1.8
RS1_1_6_5 (ss1_1_6_5 s1_1_6_5) resistor r=50
VS2_1_6_5 (ss2_1_6_5 0) vsource dc=1.8
RS2_1_6_5 (ss2_1_6_5 s2_1_6_5) resistor r=50
VI0_1_6_5 (vs0_1_6_5 0) vsource dc=0.9 mag=0
RI0_1_6_5 (vs0_1_6_5 vi0_1_6_5) resistor r=50
VI1_1_6_5 (vs1_1_6_5 0) vsource dc=0.9 mag=0
RI1_1_6_5 (vs1_1_6_5 vi1_1_6_5) resistor r=50
VI2_1_6_5 (vs2_1_6_5 0) vsource dc=0.9 mag=0
RI2_1_6_5 (vs2_1_6_5 vi2_1_6_5) resistor r=50
VI3_1_6_5 (vs3_1_6_5 0) vsource dc=0.9 mag=0
RI3_1_6_5 (vs3_1_6_5 vi3_1_6_5) resistor r=50
VI4_1_6_5 (vs4_1_6_5 0) vsource dc=0.9 mag=0
RI4_1_6_5 (vs4_1_6_5 vi4_1_6_5) resistor r=50
VI5_1_6_5 (vs5_1_6_5 0) vsource dc=0.9 mag=1
RI5_1_6_5 (vs5_1_6_5 vi5_1_6_5) resistor r=50
VI6_1_6_5 (vs6_1_6_5 0) vsource dc=0.9 mag=0
RI6_1_6_5 (vs6_1_6_5 vi6_1_6_5) resistor r=50
VI7_1_6_5 (vs7_1_6_5 0) vsource dc=0.9 mag=0
RI7_1_6_5 (vs7_1_6_5 vi7_1_6_5) resistor r=50
X1_6_5 (vdd1_6_5 0 s2_1_6_5 s1_1_6_5 s0_1_6_5 vi7_1_6_5 vi6_1_6_5 vi5_1_6_5 vi4_1_6_5 vi3_1_6_5 vi2_1_6_5 vi1_1_6_5 vi0_1_6_5 vo1_6_5) input_mux_8to1
CL1_6_5 (vo1_6_5 0) capacitor c=1p
save vo1_6_5 VDD1_6_5:p
VDD1_6_6 (vdsrc1_6_6 0) vsource dc=1.8
RVD1_6_6 (vdsrc1_6_6 vdd1_6_6) resistor r=50
VS0_1_6_6 (ss0_1_6_6 0) vsource dc=0
RS0_1_6_6 (ss0_1_6_6 s0_1_6_6) resistor r=50
VS1_1_6_6 (ss1_1_6_6 0) vsource dc=1.8
RS1_1_6_6 (ss1_1_6_6 s1_1_6_6) resistor r=50
VS2_1_6_6 (ss2_1_6_6 0) vsource dc=1.8
RS2_1_6_6 (ss2_1_6_6 s2_1_6_6) resistor r=50
VI0_1_6_6 (vs0_1_6_6 0) vsource dc=0.9 mag=0
RI0_1_6_6 (vs0_1_6_6 vi0_1_6_6) resistor r=50
VI1_1_6_6 (vs1_1_6_6 0) vsource dc=0.9 mag=0
RI1_1_6_6 (vs1_1_6_6 vi1_1_6_6) resistor r=50
VI2_1_6_6 (vs2_1_6_6 0) vsource dc=0.9 mag=0
RI2_1_6_6 (vs2_1_6_6 vi2_1_6_6) resistor r=50
VI3_1_6_6 (vs3_1_6_6 0) vsource dc=0.9 mag=0
RI3_1_6_6 (vs3_1_6_6 vi3_1_6_6) resistor r=50
VI4_1_6_6 (vs4_1_6_6 0) vsource dc=0.9 mag=0
RI4_1_6_6 (vs4_1_6_6 vi4_1_6_6) resistor r=50
VI5_1_6_6 (vs5_1_6_6 0) vsource dc=0.9 mag=0
RI5_1_6_6 (vs5_1_6_6 vi5_1_6_6) resistor r=50
VI6_1_6_6 (vs6_1_6_6 0) vsource dc=0.9 mag=1
RI6_1_6_6 (vs6_1_6_6 vi6_1_6_6) resistor r=50
VI7_1_6_6 (vs7_1_6_6 0) vsource dc=0.9 mag=0
RI7_1_6_6 (vs7_1_6_6 vi7_1_6_6) resistor r=50
X1_6_6 (vdd1_6_6 0 s2_1_6_6 s1_1_6_6 s0_1_6_6 vi7_1_6_6 vi6_1_6_6 vi5_1_6_6 vi4_1_6_6 vi3_1_6_6 vi2_1_6_6 vi1_1_6_6 vi0_1_6_6 vo1_6_6) input_mux_8to1
CL1_6_6 (vo1_6_6 0) capacitor c=1p
save vo1_6_6 VDD1_6_6:p
VDD1_6_7 (vdsrc1_6_7 0) vsource dc=1.8
RVD1_6_7 (vdsrc1_6_7 vdd1_6_7) resistor r=50
VS0_1_6_7 (ss0_1_6_7 0) vsource dc=0
RS0_1_6_7 (ss0_1_6_7 s0_1_6_7) resistor r=50
VS1_1_6_7 (ss1_1_6_7 0) vsource dc=1.8
RS1_1_6_7 (ss1_1_6_7 s1_1_6_7) resistor r=50
VS2_1_6_7 (ss2_1_6_7 0) vsource dc=1.8
RS2_1_6_7 (ss2_1_6_7 s2_1_6_7) resistor r=50
VI0_1_6_7 (vs0_1_6_7 0) vsource dc=0.9 mag=0
RI0_1_6_7 (vs0_1_6_7 vi0_1_6_7) resistor r=50
VI1_1_6_7 (vs1_1_6_7 0) vsource dc=0.9 mag=0
RI1_1_6_7 (vs1_1_6_7 vi1_1_6_7) resistor r=50
VI2_1_6_7 (vs2_1_6_7 0) vsource dc=0.9 mag=0
RI2_1_6_7 (vs2_1_6_7 vi2_1_6_7) resistor r=50
VI3_1_6_7 (vs3_1_6_7 0) vsource dc=0.9 mag=0
RI3_1_6_7 (vs3_1_6_7 vi3_1_6_7) resistor r=50
VI4_1_6_7 (vs4_1_6_7 0) vsource dc=0.9 mag=0
RI4_1_6_7 (vs4_1_6_7 vi4_1_6_7) resistor r=50
VI5_1_6_7 (vs5_1_6_7 0) vsource dc=0.9 mag=0
RI5_1_6_7 (vs5_1_6_7 vi5_1_6_7) resistor r=50
VI6_1_6_7 (vs6_1_6_7 0) vsource dc=0.9 mag=0
RI6_1_6_7 (vs6_1_6_7 vi6_1_6_7) resistor r=50
VI7_1_6_7 (vs7_1_6_7 0) vsource dc=0.9 mag=1
RI7_1_6_7 (vs7_1_6_7 vi7_1_6_7) resistor r=50
X1_6_7 (vdd1_6_7 0 s2_1_6_7 s1_1_6_7 s0_1_6_7 vi7_1_6_7 vi6_1_6_7 vi5_1_6_7 vi4_1_6_7 vi3_1_6_7 vi2_1_6_7 vi1_1_6_7 vi0_1_6_7 vo1_6_7) input_mux_8to1
CL1_6_7 (vo1_6_7 0) capacitor c=1p
save vo1_6_7 VDD1_6_7:p
VDD1_7_0 (vdsrc1_7_0 0) vsource dc=1.8
RVD1_7_0 (vdsrc1_7_0 vdd1_7_0) resistor r=50
VS0_1_7_0 (ss0_1_7_0 0) vsource dc=1.8
RS0_1_7_0 (ss0_1_7_0 s0_1_7_0) resistor r=50
VS1_1_7_0 (ss1_1_7_0 0) vsource dc=1.8
RS1_1_7_0 (ss1_1_7_0 s1_1_7_0) resistor r=50
VS2_1_7_0 (ss2_1_7_0 0) vsource dc=1.8
RS2_1_7_0 (ss2_1_7_0 s2_1_7_0) resistor r=50
VI0_1_7_0 (vs0_1_7_0 0) vsource dc=0.9 mag=1
RI0_1_7_0 (vs0_1_7_0 vi0_1_7_0) resistor r=50
VI1_1_7_0 (vs1_1_7_0 0) vsource dc=0.9 mag=0
RI1_1_7_0 (vs1_1_7_0 vi1_1_7_0) resistor r=50
VI2_1_7_0 (vs2_1_7_0 0) vsource dc=0.9 mag=0
RI2_1_7_0 (vs2_1_7_0 vi2_1_7_0) resistor r=50
VI3_1_7_0 (vs3_1_7_0 0) vsource dc=0.9 mag=0
RI3_1_7_0 (vs3_1_7_0 vi3_1_7_0) resistor r=50
VI4_1_7_0 (vs4_1_7_0 0) vsource dc=0.9 mag=0
RI4_1_7_0 (vs4_1_7_0 vi4_1_7_0) resistor r=50
VI5_1_7_0 (vs5_1_7_0 0) vsource dc=0.9 mag=0
RI5_1_7_0 (vs5_1_7_0 vi5_1_7_0) resistor r=50
VI6_1_7_0 (vs6_1_7_0 0) vsource dc=0.9 mag=0
RI6_1_7_0 (vs6_1_7_0 vi6_1_7_0) resistor r=50
VI7_1_7_0 (vs7_1_7_0 0) vsource dc=0.9 mag=0
RI7_1_7_0 (vs7_1_7_0 vi7_1_7_0) resistor r=50
X1_7_0 (vdd1_7_0 0 s2_1_7_0 s1_1_7_0 s0_1_7_0 vi7_1_7_0 vi6_1_7_0 vi5_1_7_0 vi4_1_7_0 vi3_1_7_0 vi2_1_7_0 vi1_1_7_0 vi0_1_7_0 vo1_7_0) input_mux_8to1
CL1_7_0 (vo1_7_0 0) capacitor c=1p
save vo1_7_0 VDD1_7_0:p
VDD1_7_1 (vdsrc1_7_1 0) vsource dc=1.8
RVD1_7_1 (vdsrc1_7_1 vdd1_7_1) resistor r=50
VS0_1_7_1 (ss0_1_7_1 0) vsource dc=1.8
RS0_1_7_1 (ss0_1_7_1 s0_1_7_1) resistor r=50
VS1_1_7_1 (ss1_1_7_1 0) vsource dc=1.8
RS1_1_7_1 (ss1_1_7_1 s1_1_7_1) resistor r=50
VS2_1_7_1 (ss2_1_7_1 0) vsource dc=1.8
RS2_1_7_1 (ss2_1_7_1 s2_1_7_1) resistor r=50
VI0_1_7_1 (vs0_1_7_1 0) vsource dc=0.9 mag=0
RI0_1_7_1 (vs0_1_7_1 vi0_1_7_1) resistor r=50
VI1_1_7_1 (vs1_1_7_1 0) vsource dc=0.9 mag=1
RI1_1_7_1 (vs1_1_7_1 vi1_1_7_1) resistor r=50
VI2_1_7_1 (vs2_1_7_1 0) vsource dc=0.9 mag=0
RI2_1_7_1 (vs2_1_7_1 vi2_1_7_1) resistor r=50
VI3_1_7_1 (vs3_1_7_1 0) vsource dc=0.9 mag=0
RI3_1_7_1 (vs3_1_7_1 vi3_1_7_1) resistor r=50
VI4_1_7_1 (vs4_1_7_1 0) vsource dc=0.9 mag=0
RI4_1_7_1 (vs4_1_7_1 vi4_1_7_1) resistor r=50
VI5_1_7_1 (vs5_1_7_1 0) vsource dc=0.9 mag=0
RI5_1_7_1 (vs5_1_7_1 vi5_1_7_1) resistor r=50
VI6_1_7_1 (vs6_1_7_1 0) vsource dc=0.9 mag=0
RI6_1_7_1 (vs6_1_7_1 vi6_1_7_1) resistor r=50
VI7_1_7_1 (vs7_1_7_1 0) vsource dc=0.9 mag=0
RI7_1_7_1 (vs7_1_7_1 vi7_1_7_1) resistor r=50
X1_7_1 (vdd1_7_1 0 s2_1_7_1 s1_1_7_1 s0_1_7_1 vi7_1_7_1 vi6_1_7_1 vi5_1_7_1 vi4_1_7_1 vi3_1_7_1 vi2_1_7_1 vi1_1_7_1 vi0_1_7_1 vo1_7_1) input_mux_8to1
CL1_7_1 (vo1_7_1 0) capacitor c=1p
save vo1_7_1 VDD1_7_1:p
VDD1_7_2 (vdsrc1_7_2 0) vsource dc=1.8
RVD1_7_2 (vdsrc1_7_2 vdd1_7_2) resistor r=50
VS0_1_7_2 (ss0_1_7_2 0) vsource dc=1.8
RS0_1_7_2 (ss0_1_7_2 s0_1_7_2) resistor r=50
VS1_1_7_2 (ss1_1_7_2 0) vsource dc=1.8
RS1_1_7_2 (ss1_1_7_2 s1_1_7_2) resistor r=50
VS2_1_7_2 (ss2_1_7_2 0) vsource dc=1.8
RS2_1_7_2 (ss2_1_7_2 s2_1_7_2) resistor r=50
VI0_1_7_2 (vs0_1_7_2 0) vsource dc=0.9 mag=0
RI0_1_7_2 (vs0_1_7_2 vi0_1_7_2) resistor r=50
VI1_1_7_2 (vs1_1_7_2 0) vsource dc=0.9 mag=0
RI1_1_7_2 (vs1_1_7_2 vi1_1_7_2) resistor r=50
VI2_1_7_2 (vs2_1_7_2 0) vsource dc=0.9 mag=1
RI2_1_7_2 (vs2_1_7_2 vi2_1_7_2) resistor r=50
VI3_1_7_2 (vs3_1_7_2 0) vsource dc=0.9 mag=0
RI3_1_7_2 (vs3_1_7_2 vi3_1_7_2) resistor r=50
VI4_1_7_2 (vs4_1_7_2 0) vsource dc=0.9 mag=0
RI4_1_7_2 (vs4_1_7_2 vi4_1_7_2) resistor r=50
VI5_1_7_2 (vs5_1_7_2 0) vsource dc=0.9 mag=0
RI5_1_7_2 (vs5_1_7_2 vi5_1_7_2) resistor r=50
VI6_1_7_2 (vs6_1_7_2 0) vsource dc=0.9 mag=0
RI6_1_7_2 (vs6_1_7_2 vi6_1_7_2) resistor r=50
VI7_1_7_2 (vs7_1_7_2 0) vsource dc=0.9 mag=0
RI7_1_7_2 (vs7_1_7_2 vi7_1_7_2) resistor r=50
X1_7_2 (vdd1_7_2 0 s2_1_7_2 s1_1_7_2 s0_1_7_2 vi7_1_7_2 vi6_1_7_2 vi5_1_7_2 vi4_1_7_2 vi3_1_7_2 vi2_1_7_2 vi1_1_7_2 vi0_1_7_2 vo1_7_2) input_mux_8to1
CL1_7_2 (vo1_7_2 0) capacitor c=1p
save vo1_7_2 VDD1_7_2:p
VDD1_7_3 (vdsrc1_7_3 0) vsource dc=1.8
RVD1_7_3 (vdsrc1_7_3 vdd1_7_3) resistor r=50
VS0_1_7_3 (ss0_1_7_3 0) vsource dc=1.8
RS0_1_7_3 (ss0_1_7_3 s0_1_7_3) resistor r=50
VS1_1_7_3 (ss1_1_7_3 0) vsource dc=1.8
RS1_1_7_3 (ss1_1_7_3 s1_1_7_3) resistor r=50
VS2_1_7_3 (ss2_1_7_3 0) vsource dc=1.8
RS2_1_7_3 (ss2_1_7_3 s2_1_7_3) resistor r=50
VI0_1_7_3 (vs0_1_7_3 0) vsource dc=0.9 mag=0
RI0_1_7_3 (vs0_1_7_3 vi0_1_7_3) resistor r=50
VI1_1_7_3 (vs1_1_7_3 0) vsource dc=0.9 mag=0
RI1_1_7_3 (vs1_1_7_3 vi1_1_7_3) resistor r=50
VI2_1_7_3 (vs2_1_7_3 0) vsource dc=0.9 mag=0
RI2_1_7_3 (vs2_1_7_3 vi2_1_7_3) resistor r=50
VI3_1_7_3 (vs3_1_7_3 0) vsource dc=0.9 mag=1
RI3_1_7_3 (vs3_1_7_3 vi3_1_7_3) resistor r=50
VI4_1_7_3 (vs4_1_7_3 0) vsource dc=0.9 mag=0
RI4_1_7_3 (vs4_1_7_3 vi4_1_7_3) resistor r=50
VI5_1_7_3 (vs5_1_7_3 0) vsource dc=0.9 mag=0
RI5_1_7_3 (vs5_1_7_3 vi5_1_7_3) resistor r=50
VI6_1_7_3 (vs6_1_7_3 0) vsource dc=0.9 mag=0
RI6_1_7_3 (vs6_1_7_3 vi6_1_7_3) resistor r=50
VI7_1_7_3 (vs7_1_7_3 0) vsource dc=0.9 mag=0
RI7_1_7_3 (vs7_1_7_3 vi7_1_7_3) resistor r=50
X1_7_3 (vdd1_7_3 0 s2_1_7_3 s1_1_7_3 s0_1_7_3 vi7_1_7_3 vi6_1_7_3 vi5_1_7_3 vi4_1_7_3 vi3_1_7_3 vi2_1_7_3 vi1_1_7_3 vi0_1_7_3 vo1_7_3) input_mux_8to1
CL1_7_3 (vo1_7_3 0) capacitor c=1p
save vo1_7_3 VDD1_7_3:p
VDD1_7_4 (vdsrc1_7_4 0) vsource dc=1.8
RVD1_7_4 (vdsrc1_7_4 vdd1_7_4) resistor r=50
VS0_1_7_4 (ss0_1_7_4 0) vsource dc=1.8
RS0_1_7_4 (ss0_1_7_4 s0_1_7_4) resistor r=50
VS1_1_7_4 (ss1_1_7_4 0) vsource dc=1.8
RS1_1_7_4 (ss1_1_7_4 s1_1_7_4) resistor r=50
VS2_1_7_4 (ss2_1_7_4 0) vsource dc=1.8
RS2_1_7_4 (ss2_1_7_4 s2_1_7_4) resistor r=50
VI0_1_7_4 (vs0_1_7_4 0) vsource dc=0.9 mag=0
RI0_1_7_4 (vs0_1_7_4 vi0_1_7_4) resistor r=50
VI1_1_7_4 (vs1_1_7_4 0) vsource dc=0.9 mag=0
RI1_1_7_4 (vs1_1_7_4 vi1_1_7_4) resistor r=50
VI2_1_7_4 (vs2_1_7_4 0) vsource dc=0.9 mag=0
RI2_1_7_4 (vs2_1_7_4 vi2_1_7_4) resistor r=50
VI3_1_7_4 (vs3_1_7_4 0) vsource dc=0.9 mag=0
RI3_1_7_4 (vs3_1_7_4 vi3_1_7_4) resistor r=50
VI4_1_7_4 (vs4_1_7_4 0) vsource dc=0.9 mag=1
RI4_1_7_4 (vs4_1_7_4 vi4_1_7_4) resistor r=50
VI5_1_7_4 (vs5_1_7_4 0) vsource dc=0.9 mag=0
RI5_1_7_4 (vs5_1_7_4 vi5_1_7_4) resistor r=50
VI6_1_7_4 (vs6_1_7_4 0) vsource dc=0.9 mag=0
RI6_1_7_4 (vs6_1_7_4 vi6_1_7_4) resistor r=50
VI7_1_7_4 (vs7_1_7_4 0) vsource dc=0.9 mag=0
RI7_1_7_4 (vs7_1_7_4 vi7_1_7_4) resistor r=50
X1_7_4 (vdd1_7_4 0 s2_1_7_4 s1_1_7_4 s0_1_7_4 vi7_1_7_4 vi6_1_7_4 vi5_1_7_4 vi4_1_7_4 vi3_1_7_4 vi2_1_7_4 vi1_1_7_4 vi0_1_7_4 vo1_7_4) input_mux_8to1
CL1_7_4 (vo1_7_4 0) capacitor c=1p
save vo1_7_4 VDD1_7_4:p
VDD1_7_5 (vdsrc1_7_5 0) vsource dc=1.8
RVD1_7_5 (vdsrc1_7_5 vdd1_7_5) resistor r=50
VS0_1_7_5 (ss0_1_7_5 0) vsource dc=1.8
RS0_1_7_5 (ss0_1_7_5 s0_1_7_5) resistor r=50
VS1_1_7_5 (ss1_1_7_5 0) vsource dc=1.8
RS1_1_7_5 (ss1_1_7_5 s1_1_7_5) resistor r=50
VS2_1_7_5 (ss2_1_7_5 0) vsource dc=1.8
RS2_1_7_5 (ss2_1_7_5 s2_1_7_5) resistor r=50
VI0_1_7_5 (vs0_1_7_5 0) vsource dc=0.9 mag=0
RI0_1_7_5 (vs0_1_7_5 vi0_1_7_5) resistor r=50
VI1_1_7_5 (vs1_1_7_5 0) vsource dc=0.9 mag=0
RI1_1_7_5 (vs1_1_7_5 vi1_1_7_5) resistor r=50
VI2_1_7_5 (vs2_1_7_5 0) vsource dc=0.9 mag=0
RI2_1_7_5 (vs2_1_7_5 vi2_1_7_5) resistor r=50
VI3_1_7_5 (vs3_1_7_5 0) vsource dc=0.9 mag=0
RI3_1_7_5 (vs3_1_7_5 vi3_1_7_5) resistor r=50
VI4_1_7_5 (vs4_1_7_5 0) vsource dc=0.9 mag=0
RI4_1_7_5 (vs4_1_7_5 vi4_1_7_5) resistor r=50
VI5_1_7_5 (vs5_1_7_5 0) vsource dc=0.9 mag=1
RI5_1_7_5 (vs5_1_7_5 vi5_1_7_5) resistor r=50
VI6_1_7_5 (vs6_1_7_5 0) vsource dc=0.9 mag=0
RI6_1_7_5 (vs6_1_7_5 vi6_1_7_5) resistor r=50
VI7_1_7_5 (vs7_1_7_5 0) vsource dc=0.9 mag=0
RI7_1_7_5 (vs7_1_7_5 vi7_1_7_5) resistor r=50
X1_7_5 (vdd1_7_5 0 s2_1_7_5 s1_1_7_5 s0_1_7_5 vi7_1_7_5 vi6_1_7_5 vi5_1_7_5 vi4_1_7_5 vi3_1_7_5 vi2_1_7_5 vi1_1_7_5 vi0_1_7_5 vo1_7_5) input_mux_8to1
CL1_7_5 (vo1_7_5 0) capacitor c=1p
save vo1_7_5 VDD1_7_5:p
VDD1_7_6 (vdsrc1_7_6 0) vsource dc=1.8
RVD1_7_6 (vdsrc1_7_6 vdd1_7_6) resistor r=50
VS0_1_7_6 (ss0_1_7_6 0) vsource dc=1.8
RS0_1_7_6 (ss0_1_7_6 s0_1_7_6) resistor r=50
VS1_1_7_6 (ss1_1_7_6 0) vsource dc=1.8
RS1_1_7_6 (ss1_1_7_6 s1_1_7_6) resistor r=50
VS2_1_7_6 (ss2_1_7_6 0) vsource dc=1.8
RS2_1_7_6 (ss2_1_7_6 s2_1_7_6) resistor r=50
VI0_1_7_6 (vs0_1_7_6 0) vsource dc=0.9 mag=0
RI0_1_7_6 (vs0_1_7_6 vi0_1_7_6) resistor r=50
VI1_1_7_6 (vs1_1_7_6 0) vsource dc=0.9 mag=0
RI1_1_7_6 (vs1_1_7_6 vi1_1_7_6) resistor r=50
VI2_1_7_6 (vs2_1_7_6 0) vsource dc=0.9 mag=0
RI2_1_7_6 (vs2_1_7_6 vi2_1_7_6) resistor r=50
VI3_1_7_6 (vs3_1_7_6 0) vsource dc=0.9 mag=0
RI3_1_7_6 (vs3_1_7_6 vi3_1_7_6) resistor r=50
VI4_1_7_6 (vs4_1_7_6 0) vsource dc=0.9 mag=0
RI4_1_7_6 (vs4_1_7_6 vi4_1_7_6) resistor r=50
VI5_1_7_6 (vs5_1_7_6 0) vsource dc=0.9 mag=0
RI5_1_7_6 (vs5_1_7_6 vi5_1_7_6) resistor r=50
VI6_1_7_6 (vs6_1_7_6 0) vsource dc=0.9 mag=1
RI6_1_7_6 (vs6_1_7_6 vi6_1_7_6) resistor r=50
VI7_1_7_6 (vs7_1_7_6 0) vsource dc=0.9 mag=0
RI7_1_7_6 (vs7_1_7_6 vi7_1_7_6) resistor r=50
X1_7_6 (vdd1_7_6 0 s2_1_7_6 s1_1_7_6 s0_1_7_6 vi7_1_7_6 vi6_1_7_6 vi5_1_7_6 vi4_1_7_6 vi3_1_7_6 vi2_1_7_6 vi1_1_7_6 vi0_1_7_6 vo1_7_6) input_mux_8to1
CL1_7_6 (vo1_7_6 0) capacitor c=1p
save vo1_7_6 VDD1_7_6:p
VDD1_7_7 (vdsrc1_7_7 0) vsource dc=1.8
RVD1_7_7 (vdsrc1_7_7 vdd1_7_7) resistor r=50
VS0_1_7_7 (ss0_1_7_7 0) vsource dc=1.8
RS0_1_7_7 (ss0_1_7_7 s0_1_7_7) resistor r=50
VS1_1_7_7 (ss1_1_7_7 0) vsource dc=1.8
RS1_1_7_7 (ss1_1_7_7 s1_1_7_7) resistor r=50
VS2_1_7_7 (ss2_1_7_7 0) vsource dc=1.8
RS2_1_7_7 (ss2_1_7_7 s2_1_7_7) resistor r=50
VI0_1_7_7 (vs0_1_7_7 0) vsource dc=0.9 mag=0
RI0_1_7_7 (vs0_1_7_7 vi0_1_7_7) resistor r=50
VI1_1_7_7 (vs1_1_7_7 0) vsource dc=0.9 mag=0
RI1_1_7_7 (vs1_1_7_7 vi1_1_7_7) resistor r=50
VI2_1_7_7 (vs2_1_7_7 0) vsource dc=0.9 mag=0
RI2_1_7_7 (vs2_1_7_7 vi2_1_7_7) resistor r=50
VI3_1_7_7 (vs3_1_7_7 0) vsource dc=0.9 mag=0
RI3_1_7_7 (vs3_1_7_7 vi3_1_7_7) resistor r=50
VI4_1_7_7 (vs4_1_7_7 0) vsource dc=0.9 mag=0
RI4_1_7_7 (vs4_1_7_7 vi4_1_7_7) resistor r=50
VI5_1_7_7 (vs5_1_7_7 0) vsource dc=0.9 mag=0
RI5_1_7_7 (vs5_1_7_7 vi5_1_7_7) resistor r=50
VI6_1_7_7 (vs6_1_7_7 0) vsource dc=0.9 mag=0
RI6_1_7_7 (vs6_1_7_7 vi6_1_7_7) resistor r=50
VI7_1_7_7 (vs7_1_7_7 0) vsource dc=0.9 mag=1
RI7_1_7_7 (vs7_1_7_7 vi7_1_7_7) resistor r=50
X1_7_7 (vdd1_7_7 0 s2_1_7_7 s1_1_7_7 s0_1_7_7 vi7_1_7_7 vi6_1_7_7 vi5_1_7_7 vi4_1_7_7 vi3_1_7_7 vi2_1_7_7 vi1_1_7_7 vi0_1_7_7 vo1_7_7) input_mux_8to1
CL1_7_7 (vo1_7_7 0) capacitor c=1p
save vo1_7_7 VDD1_7_7:p
VDD2_0_0 (vdsrc2_0_0 0) vsource dc=1.8
RVD2_0_0 (vdsrc2_0_0 vdd2_0_0) resistor r=50
VS0_2_0_0 (ss0_2_0_0 0) vsource dc=0
RS0_2_0_0 (ss0_2_0_0 s0_2_0_0) resistor r=50
VS1_2_0_0 (ss1_2_0_0 0) vsource dc=0
RS1_2_0_0 (ss1_2_0_0 s1_2_0_0) resistor r=50
VS2_2_0_0 (ss2_2_0_0 0) vsource dc=0
RS2_2_0_0 (ss2_2_0_0 s2_2_0_0) resistor r=50
VI0_2_0_0 (vs0_2_0_0 0) vsource dc=1.8 mag=1
RI0_2_0_0 (vs0_2_0_0 vi0_2_0_0) resistor r=50
VI1_2_0_0 (vs1_2_0_0 0) vsource dc=1.8 mag=0
RI1_2_0_0 (vs1_2_0_0 vi1_2_0_0) resistor r=50
VI2_2_0_0 (vs2_2_0_0 0) vsource dc=1.8 mag=0
RI2_2_0_0 (vs2_2_0_0 vi2_2_0_0) resistor r=50
VI3_2_0_0 (vs3_2_0_0 0) vsource dc=1.8 mag=0
RI3_2_0_0 (vs3_2_0_0 vi3_2_0_0) resistor r=50
VI4_2_0_0 (vs4_2_0_0 0) vsource dc=1.8 mag=0
RI4_2_0_0 (vs4_2_0_0 vi4_2_0_0) resistor r=50
VI5_2_0_0 (vs5_2_0_0 0) vsource dc=1.8 mag=0
RI5_2_0_0 (vs5_2_0_0 vi5_2_0_0) resistor r=50
VI6_2_0_0 (vs6_2_0_0 0) vsource dc=1.8 mag=0
RI6_2_0_0 (vs6_2_0_0 vi6_2_0_0) resistor r=50
VI7_2_0_0 (vs7_2_0_0 0) vsource dc=1.8 mag=0
RI7_2_0_0 (vs7_2_0_0 vi7_2_0_0) resistor r=50
X2_0_0 (vdd2_0_0 0 s2_2_0_0 s1_2_0_0 s0_2_0_0 vi7_2_0_0 vi6_2_0_0 vi5_2_0_0 vi4_2_0_0 vi3_2_0_0 vi2_2_0_0 vi1_2_0_0 vi0_2_0_0 vo2_0_0) input_mux_8to1
CL2_0_0 (vo2_0_0 0) capacitor c=1p
save vo2_0_0 VDD2_0_0:p
save X2_0_0.XSW0.MN:gds
save X2_0_0.XSW0.MP:gds
save X2_0_0.XSW8.MN:gds
save X2_0_0.XSW8.MP:gds
save X2_0_0.XSW12.MN:gds
save X2_0_0.XSW12.MP:gds
VDD2_0_1 (vdsrc2_0_1 0) vsource dc=1.8
RVD2_0_1 (vdsrc2_0_1 vdd2_0_1) resistor r=50
VS0_2_0_1 (ss0_2_0_1 0) vsource dc=0
RS0_2_0_1 (ss0_2_0_1 s0_2_0_1) resistor r=50
VS1_2_0_1 (ss1_2_0_1 0) vsource dc=0
RS1_2_0_1 (ss1_2_0_1 s1_2_0_1) resistor r=50
VS2_2_0_1 (ss2_2_0_1 0) vsource dc=0
RS2_2_0_1 (ss2_2_0_1 s2_2_0_1) resistor r=50
VI0_2_0_1 (vs0_2_0_1 0) vsource dc=1.8 mag=0
RI0_2_0_1 (vs0_2_0_1 vi0_2_0_1) resistor r=50
VI1_2_0_1 (vs1_2_0_1 0) vsource dc=1.8 mag=1
RI1_2_0_1 (vs1_2_0_1 vi1_2_0_1) resistor r=50
VI2_2_0_1 (vs2_2_0_1 0) vsource dc=1.8 mag=0
RI2_2_0_1 (vs2_2_0_1 vi2_2_0_1) resistor r=50
VI3_2_0_1 (vs3_2_0_1 0) vsource dc=1.8 mag=0
RI3_2_0_1 (vs3_2_0_1 vi3_2_0_1) resistor r=50
VI4_2_0_1 (vs4_2_0_1 0) vsource dc=1.8 mag=0
RI4_2_0_1 (vs4_2_0_1 vi4_2_0_1) resistor r=50
VI5_2_0_1 (vs5_2_0_1 0) vsource dc=1.8 mag=0
RI5_2_0_1 (vs5_2_0_1 vi5_2_0_1) resistor r=50
VI6_2_0_1 (vs6_2_0_1 0) vsource dc=1.8 mag=0
RI6_2_0_1 (vs6_2_0_1 vi6_2_0_1) resistor r=50
VI7_2_0_1 (vs7_2_0_1 0) vsource dc=1.8 mag=0
RI7_2_0_1 (vs7_2_0_1 vi7_2_0_1) resistor r=50
X2_0_1 (vdd2_0_1 0 s2_2_0_1 s1_2_0_1 s0_2_0_1 vi7_2_0_1 vi6_2_0_1 vi5_2_0_1 vi4_2_0_1 vi3_2_0_1 vi2_2_0_1 vi1_2_0_1 vi0_2_0_1 vo2_0_1) input_mux_8to1
CL2_0_1 (vo2_0_1 0) capacitor c=1p
save vo2_0_1 VDD2_0_1:p
VDD2_0_2 (vdsrc2_0_2 0) vsource dc=1.8
RVD2_0_2 (vdsrc2_0_2 vdd2_0_2) resistor r=50
VS0_2_0_2 (ss0_2_0_2 0) vsource dc=0
RS0_2_0_2 (ss0_2_0_2 s0_2_0_2) resistor r=50
VS1_2_0_2 (ss1_2_0_2 0) vsource dc=0
RS1_2_0_2 (ss1_2_0_2 s1_2_0_2) resistor r=50
VS2_2_0_2 (ss2_2_0_2 0) vsource dc=0
RS2_2_0_2 (ss2_2_0_2 s2_2_0_2) resistor r=50
VI0_2_0_2 (vs0_2_0_2 0) vsource dc=1.8 mag=0
RI0_2_0_2 (vs0_2_0_2 vi0_2_0_2) resistor r=50
VI1_2_0_2 (vs1_2_0_2 0) vsource dc=1.8 mag=0
RI1_2_0_2 (vs1_2_0_2 vi1_2_0_2) resistor r=50
VI2_2_0_2 (vs2_2_0_2 0) vsource dc=1.8 mag=1
RI2_2_0_2 (vs2_2_0_2 vi2_2_0_2) resistor r=50
VI3_2_0_2 (vs3_2_0_2 0) vsource dc=1.8 mag=0
RI3_2_0_2 (vs3_2_0_2 vi3_2_0_2) resistor r=50
VI4_2_0_2 (vs4_2_0_2 0) vsource dc=1.8 mag=0
RI4_2_0_2 (vs4_2_0_2 vi4_2_0_2) resistor r=50
VI5_2_0_2 (vs5_2_0_2 0) vsource dc=1.8 mag=0
RI5_2_0_2 (vs5_2_0_2 vi5_2_0_2) resistor r=50
VI6_2_0_2 (vs6_2_0_2 0) vsource dc=1.8 mag=0
RI6_2_0_2 (vs6_2_0_2 vi6_2_0_2) resistor r=50
VI7_2_0_2 (vs7_2_0_2 0) vsource dc=1.8 mag=0
RI7_2_0_2 (vs7_2_0_2 vi7_2_0_2) resistor r=50
X2_0_2 (vdd2_0_2 0 s2_2_0_2 s1_2_0_2 s0_2_0_2 vi7_2_0_2 vi6_2_0_2 vi5_2_0_2 vi4_2_0_2 vi3_2_0_2 vi2_2_0_2 vi1_2_0_2 vi0_2_0_2 vo2_0_2) input_mux_8to1
CL2_0_2 (vo2_0_2 0) capacitor c=1p
save vo2_0_2 VDD2_0_2:p
VDD2_0_3 (vdsrc2_0_3 0) vsource dc=1.8
RVD2_0_3 (vdsrc2_0_3 vdd2_0_3) resistor r=50
VS0_2_0_3 (ss0_2_0_3 0) vsource dc=0
RS0_2_0_3 (ss0_2_0_3 s0_2_0_3) resistor r=50
VS1_2_0_3 (ss1_2_0_3 0) vsource dc=0
RS1_2_0_3 (ss1_2_0_3 s1_2_0_3) resistor r=50
VS2_2_0_3 (ss2_2_0_3 0) vsource dc=0
RS2_2_0_3 (ss2_2_0_3 s2_2_0_3) resistor r=50
VI0_2_0_3 (vs0_2_0_3 0) vsource dc=1.8 mag=0
RI0_2_0_3 (vs0_2_0_3 vi0_2_0_3) resistor r=50
VI1_2_0_3 (vs1_2_0_3 0) vsource dc=1.8 mag=0
RI1_2_0_3 (vs1_2_0_3 vi1_2_0_3) resistor r=50
VI2_2_0_3 (vs2_2_0_3 0) vsource dc=1.8 mag=0
RI2_2_0_3 (vs2_2_0_3 vi2_2_0_3) resistor r=50
VI3_2_0_3 (vs3_2_0_3 0) vsource dc=1.8 mag=1
RI3_2_0_3 (vs3_2_0_3 vi3_2_0_3) resistor r=50
VI4_2_0_3 (vs4_2_0_3 0) vsource dc=1.8 mag=0
RI4_2_0_3 (vs4_2_0_3 vi4_2_0_3) resistor r=50
VI5_2_0_3 (vs5_2_0_3 0) vsource dc=1.8 mag=0
RI5_2_0_3 (vs5_2_0_3 vi5_2_0_3) resistor r=50
VI6_2_0_3 (vs6_2_0_3 0) vsource dc=1.8 mag=0
RI6_2_0_3 (vs6_2_0_3 vi6_2_0_3) resistor r=50
VI7_2_0_3 (vs7_2_0_3 0) vsource dc=1.8 mag=0
RI7_2_0_3 (vs7_2_0_3 vi7_2_0_3) resistor r=50
X2_0_3 (vdd2_0_3 0 s2_2_0_3 s1_2_0_3 s0_2_0_3 vi7_2_0_3 vi6_2_0_3 vi5_2_0_3 vi4_2_0_3 vi3_2_0_3 vi2_2_0_3 vi1_2_0_3 vi0_2_0_3 vo2_0_3) input_mux_8to1
CL2_0_3 (vo2_0_3 0) capacitor c=1p
save vo2_0_3 VDD2_0_3:p
VDD2_0_4 (vdsrc2_0_4 0) vsource dc=1.8
RVD2_0_4 (vdsrc2_0_4 vdd2_0_4) resistor r=50
VS0_2_0_4 (ss0_2_0_4 0) vsource dc=0
RS0_2_0_4 (ss0_2_0_4 s0_2_0_4) resistor r=50
VS1_2_0_4 (ss1_2_0_4 0) vsource dc=0
RS1_2_0_4 (ss1_2_0_4 s1_2_0_4) resistor r=50
VS2_2_0_4 (ss2_2_0_4 0) vsource dc=0
RS2_2_0_4 (ss2_2_0_4 s2_2_0_4) resistor r=50
VI0_2_0_4 (vs0_2_0_4 0) vsource dc=1.8 mag=0
RI0_2_0_4 (vs0_2_0_4 vi0_2_0_4) resistor r=50
VI1_2_0_4 (vs1_2_0_4 0) vsource dc=1.8 mag=0
RI1_2_0_4 (vs1_2_0_4 vi1_2_0_4) resistor r=50
VI2_2_0_4 (vs2_2_0_4 0) vsource dc=1.8 mag=0
RI2_2_0_4 (vs2_2_0_4 vi2_2_0_4) resistor r=50
VI3_2_0_4 (vs3_2_0_4 0) vsource dc=1.8 mag=0
RI3_2_0_4 (vs3_2_0_4 vi3_2_0_4) resistor r=50
VI4_2_0_4 (vs4_2_0_4 0) vsource dc=1.8 mag=1
RI4_2_0_4 (vs4_2_0_4 vi4_2_0_4) resistor r=50
VI5_2_0_4 (vs5_2_0_4 0) vsource dc=1.8 mag=0
RI5_2_0_4 (vs5_2_0_4 vi5_2_0_4) resistor r=50
VI6_2_0_4 (vs6_2_0_4 0) vsource dc=1.8 mag=0
RI6_2_0_4 (vs6_2_0_4 vi6_2_0_4) resistor r=50
VI7_2_0_4 (vs7_2_0_4 0) vsource dc=1.8 mag=0
RI7_2_0_4 (vs7_2_0_4 vi7_2_0_4) resistor r=50
X2_0_4 (vdd2_0_4 0 s2_2_0_4 s1_2_0_4 s0_2_0_4 vi7_2_0_4 vi6_2_0_4 vi5_2_0_4 vi4_2_0_4 vi3_2_0_4 vi2_2_0_4 vi1_2_0_4 vi0_2_0_4 vo2_0_4) input_mux_8to1
CL2_0_4 (vo2_0_4 0) capacitor c=1p
save vo2_0_4 VDD2_0_4:p
VDD2_0_5 (vdsrc2_0_5 0) vsource dc=1.8
RVD2_0_5 (vdsrc2_0_5 vdd2_0_5) resistor r=50
VS0_2_0_5 (ss0_2_0_5 0) vsource dc=0
RS0_2_0_5 (ss0_2_0_5 s0_2_0_5) resistor r=50
VS1_2_0_5 (ss1_2_0_5 0) vsource dc=0
RS1_2_0_5 (ss1_2_0_5 s1_2_0_5) resistor r=50
VS2_2_0_5 (ss2_2_0_5 0) vsource dc=0
RS2_2_0_5 (ss2_2_0_5 s2_2_0_5) resistor r=50
VI0_2_0_5 (vs0_2_0_5 0) vsource dc=1.8 mag=0
RI0_2_0_5 (vs0_2_0_5 vi0_2_0_5) resistor r=50
VI1_2_0_5 (vs1_2_0_5 0) vsource dc=1.8 mag=0
RI1_2_0_5 (vs1_2_0_5 vi1_2_0_5) resistor r=50
VI2_2_0_5 (vs2_2_0_5 0) vsource dc=1.8 mag=0
RI2_2_0_5 (vs2_2_0_5 vi2_2_0_5) resistor r=50
VI3_2_0_5 (vs3_2_0_5 0) vsource dc=1.8 mag=0
RI3_2_0_5 (vs3_2_0_5 vi3_2_0_5) resistor r=50
VI4_2_0_5 (vs4_2_0_5 0) vsource dc=1.8 mag=0
RI4_2_0_5 (vs4_2_0_5 vi4_2_0_5) resistor r=50
VI5_2_0_5 (vs5_2_0_5 0) vsource dc=1.8 mag=1
RI5_2_0_5 (vs5_2_0_5 vi5_2_0_5) resistor r=50
VI6_2_0_5 (vs6_2_0_5 0) vsource dc=1.8 mag=0
RI6_2_0_5 (vs6_2_0_5 vi6_2_0_5) resistor r=50
VI7_2_0_5 (vs7_2_0_5 0) vsource dc=1.8 mag=0
RI7_2_0_5 (vs7_2_0_5 vi7_2_0_5) resistor r=50
X2_0_5 (vdd2_0_5 0 s2_2_0_5 s1_2_0_5 s0_2_0_5 vi7_2_0_5 vi6_2_0_5 vi5_2_0_5 vi4_2_0_5 vi3_2_0_5 vi2_2_0_5 vi1_2_0_5 vi0_2_0_5 vo2_0_5) input_mux_8to1
CL2_0_5 (vo2_0_5 0) capacitor c=1p
save vo2_0_5 VDD2_0_5:p
VDD2_0_6 (vdsrc2_0_6 0) vsource dc=1.8
RVD2_0_6 (vdsrc2_0_6 vdd2_0_6) resistor r=50
VS0_2_0_6 (ss0_2_0_6 0) vsource dc=0
RS0_2_0_6 (ss0_2_0_6 s0_2_0_6) resistor r=50
VS1_2_0_6 (ss1_2_0_6 0) vsource dc=0
RS1_2_0_6 (ss1_2_0_6 s1_2_0_6) resistor r=50
VS2_2_0_6 (ss2_2_0_6 0) vsource dc=0
RS2_2_0_6 (ss2_2_0_6 s2_2_0_6) resistor r=50
VI0_2_0_6 (vs0_2_0_6 0) vsource dc=1.8 mag=0
RI0_2_0_6 (vs0_2_0_6 vi0_2_0_6) resistor r=50
VI1_2_0_6 (vs1_2_0_6 0) vsource dc=1.8 mag=0
RI1_2_0_6 (vs1_2_0_6 vi1_2_0_6) resistor r=50
VI2_2_0_6 (vs2_2_0_6 0) vsource dc=1.8 mag=0
RI2_2_0_6 (vs2_2_0_6 vi2_2_0_6) resistor r=50
VI3_2_0_6 (vs3_2_0_6 0) vsource dc=1.8 mag=0
RI3_2_0_6 (vs3_2_0_6 vi3_2_0_6) resistor r=50
VI4_2_0_6 (vs4_2_0_6 0) vsource dc=1.8 mag=0
RI4_2_0_6 (vs4_2_0_6 vi4_2_0_6) resistor r=50
VI5_2_0_6 (vs5_2_0_6 0) vsource dc=1.8 mag=0
RI5_2_0_6 (vs5_2_0_6 vi5_2_0_6) resistor r=50
VI6_2_0_6 (vs6_2_0_6 0) vsource dc=1.8 mag=1
RI6_2_0_6 (vs6_2_0_6 vi6_2_0_6) resistor r=50
VI7_2_0_6 (vs7_2_0_6 0) vsource dc=1.8 mag=0
RI7_2_0_6 (vs7_2_0_6 vi7_2_0_6) resistor r=50
X2_0_6 (vdd2_0_6 0 s2_2_0_6 s1_2_0_6 s0_2_0_6 vi7_2_0_6 vi6_2_0_6 vi5_2_0_6 vi4_2_0_6 vi3_2_0_6 vi2_2_0_6 vi1_2_0_6 vi0_2_0_6 vo2_0_6) input_mux_8to1
CL2_0_6 (vo2_0_6 0) capacitor c=1p
save vo2_0_6 VDD2_0_6:p
VDD2_0_7 (vdsrc2_0_7 0) vsource dc=1.8
RVD2_0_7 (vdsrc2_0_7 vdd2_0_7) resistor r=50
VS0_2_0_7 (ss0_2_0_7 0) vsource dc=0
RS0_2_0_7 (ss0_2_0_7 s0_2_0_7) resistor r=50
VS1_2_0_7 (ss1_2_0_7 0) vsource dc=0
RS1_2_0_7 (ss1_2_0_7 s1_2_0_7) resistor r=50
VS2_2_0_7 (ss2_2_0_7 0) vsource dc=0
RS2_2_0_7 (ss2_2_0_7 s2_2_0_7) resistor r=50
VI0_2_0_7 (vs0_2_0_7 0) vsource dc=1.8 mag=0
RI0_2_0_7 (vs0_2_0_7 vi0_2_0_7) resistor r=50
VI1_2_0_7 (vs1_2_0_7 0) vsource dc=1.8 mag=0
RI1_2_0_7 (vs1_2_0_7 vi1_2_0_7) resistor r=50
VI2_2_0_7 (vs2_2_0_7 0) vsource dc=1.8 mag=0
RI2_2_0_7 (vs2_2_0_7 vi2_2_0_7) resistor r=50
VI3_2_0_7 (vs3_2_0_7 0) vsource dc=1.8 mag=0
RI3_2_0_7 (vs3_2_0_7 vi3_2_0_7) resistor r=50
VI4_2_0_7 (vs4_2_0_7 0) vsource dc=1.8 mag=0
RI4_2_0_7 (vs4_2_0_7 vi4_2_0_7) resistor r=50
VI5_2_0_7 (vs5_2_0_7 0) vsource dc=1.8 mag=0
RI5_2_0_7 (vs5_2_0_7 vi5_2_0_7) resistor r=50
VI6_2_0_7 (vs6_2_0_7 0) vsource dc=1.8 mag=0
RI6_2_0_7 (vs6_2_0_7 vi6_2_0_7) resistor r=50
VI7_2_0_7 (vs7_2_0_7 0) vsource dc=1.8 mag=1
RI7_2_0_7 (vs7_2_0_7 vi7_2_0_7) resistor r=50
X2_0_7 (vdd2_0_7 0 s2_2_0_7 s1_2_0_7 s0_2_0_7 vi7_2_0_7 vi6_2_0_7 vi5_2_0_7 vi4_2_0_7 vi3_2_0_7 vi2_2_0_7 vi1_2_0_7 vi0_2_0_7 vo2_0_7) input_mux_8to1
CL2_0_7 (vo2_0_7 0) capacitor c=1p
save vo2_0_7 VDD2_0_7:p
VDD2_1_0 (vdsrc2_1_0 0) vsource dc=1.8
RVD2_1_0 (vdsrc2_1_0 vdd2_1_0) resistor r=50
VS0_2_1_0 (ss0_2_1_0 0) vsource dc=1.8
RS0_2_1_0 (ss0_2_1_0 s0_2_1_0) resistor r=50
VS1_2_1_0 (ss1_2_1_0 0) vsource dc=0
RS1_2_1_0 (ss1_2_1_0 s1_2_1_0) resistor r=50
VS2_2_1_0 (ss2_2_1_0 0) vsource dc=0
RS2_2_1_0 (ss2_2_1_0 s2_2_1_0) resistor r=50
VI0_2_1_0 (vs0_2_1_0 0) vsource dc=1.8 mag=1
RI0_2_1_0 (vs0_2_1_0 vi0_2_1_0) resistor r=50
VI1_2_1_0 (vs1_2_1_0 0) vsource dc=1.8 mag=0
RI1_2_1_0 (vs1_2_1_0 vi1_2_1_0) resistor r=50
VI2_2_1_0 (vs2_2_1_0 0) vsource dc=1.8 mag=0
RI2_2_1_0 (vs2_2_1_0 vi2_2_1_0) resistor r=50
VI3_2_1_0 (vs3_2_1_0 0) vsource dc=1.8 mag=0
RI3_2_1_0 (vs3_2_1_0 vi3_2_1_0) resistor r=50
VI4_2_1_0 (vs4_2_1_0 0) vsource dc=1.8 mag=0
RI4_2_1_0 (vs4_2_1_0 vi4_2_1_0) resistor r=50
VI5_2_1_0 (vs5_2_1_0 0) vsource dc=1.8 mag=0
RI5_2_1_0 (vs5_2_1_0 vi5_2_1_0) resistor r=50
VI6_2_1_0 (vs6_2_1_0 0) vsource dc=1.8 mag=0
RI6_2_1_0 (vs6_2_1_0 vi6_2_1_0) resistor r=50
VI7_2_1_0 (vs7_2_1_0 0) vsource dc=1.8 mag=0
RI7_2_1_0 (vs7_2_1_0 vi7_2_1_0) resistor r=50
X2_1_0 (vdd2_1_0 0 s2_2_1_0 s1_2_1_0 s0_2_1_0 vi7_2_1_0 vi6_2_1_0 vi5_2_1_0 vi4_2_1_0 vi3_2_1_0 vi2_2_1_0 vi1_2_1_0 vi0_2_1_0 vo2_1_0) input_mux_8to1
CL2_1_0 (vo2_1_0 0) capacitor c=1p
save vo2_1_0 VDD2_1_0:p
VDD2_1_1 (vdsrc2_1_1 0) vsource dc=1.8
RVD2_1_1 (vdsrc2_1_1 vdd2_1_1) resistor r=50
VS0_2_1_1 (ss0_2_1_1 0) vsource dc=1.8
RS0_2_1_1 (ss0_2_1_1 s0_2_1_1) resistor r=50
VS1_2_1_1 (ss1_2_1_1 0) vsource dc=0
RS1_2_1_1 (ss1_2_1_1 s1_2_1_1) resistor r=50
VS2_2_1_1 (ss2_2_1_1 0) vsource dc=0
RS2_2_1_1 (ss2_2_1_1 s2_2_1_1) resistor r=50
VI0_2_1_1 (vs0_2_1_1 0) vsource dc=1.8 mag=0
RI0_2_1_1 (vs0_2_1_1 vi0_2_1_1) resistor r=50
VI1_2_1_1 (vs1_2_1_1 0) vsource dc=1.8 mag=1
RI1_2_1_1 (vs1_2_1_1 vi1_2_1_1) resistor r=50
VI2_2_1_1 (vs2_2_1_1 0) vsource dc=1.8 mag=0
RI2_2_1_1 (vs2_2_1_1 vi2_2_1_1) resistor r=50
VI3_2_1_1 (vs3_2_1_1 0) vsource dc=1.8 mag=0
RI3_2_1_1 (vs3_2_1_1 vi3_2_1_1) resistor r=50
VI4_2_1_1 (vs4_2_1_1 0) vsource dc=1.8 mag=0
RI4_2_1_1 (vs4_2_1_1 vi4_2_1_1) resistor r=50
VI5_2_1_1 (vs5_2_1_1 0) vsource dc=1.8 mag=0
RI5_2_1_1 (vs5_2_1_1 vi5_2_1_1) resistor r=50
VI6_2_1_1 (vs6_2_1_1 0) vsource dc=1.8 mag=0
RI6_2_1_1 (vs6_2_1_1 vi6_2_1_1) resistor r=50
VI7_2_1_1 (vs7_2_1_1 0) vsource dc=1.8 mag=0
RI7_2_1_1 (vs7_2_1_1 vi7_2_1_1) resistor r=50
X2_1_1 (vdd2_1_1 0 s2_2_1_1 s1_2_1_1 s0_2_1_1 vi7_2_1_1 vi6_2_1_1 vi5_2_1_1 vi4_2_1_1 vi3_2_1_1 vi2_2_1_1 vi1_2_1_1 vi0_2_1_1 vo2_1_1) input_mux_8to1
CL2_1_1 (vo2_1_1 0) capacitor c=1p
save vo2_1_1 VDD2_1_1:p
VDD2_1_2 (vdsrc2_1_2 0) vsource dc=1.8
RVD2_1_2 (vdsrc2_1_2 vdd2_1_2) resistor r=50
VS0_2_1_2 (ss0_2_1_2 0) vsource dc=1.8
RS0_2_1_2 (ss0_2_1_2 s0_2_1_2) resistor r=50
VS1_2_1_2 (ss1_2_1_2 0) vsource dc=0
RS1_2_1_2 (ss1_2_1_2 s1_2_1_2) resistor r=50
VS2_2_1_2 (ss2_2_1_2 0) vsource dc=0
RS2_2_1_2 (ss2_2_1_2 s2_2_1_2) resistor r=50
VI0_2_1_2 (vs0_2_1_2 0) vsource dc=1.8 mag=0
RI0_2_1_2 (vs0_2_1_2 vi0_2_1_2) resistor r=50
VI1_2_1_2 (vs1_2_1_2 0) vsource dc=1.8 mag=0
RI1_2_1_2 (vs1_2_1_2 vi1_2_1_2) resistor r=50
VI2_2_1_2 (vs2_2_1_2 0) vsource dc=1.8 mag=1
RI2_2_1_2 (vs2_2_1_2 vi2_2_1_2) resistor r=50
VI3_2_1_2 (vs3_2_1_2 0) vsource dc=1.8 mag=0
RI3_2_1_2 (vs3_2_1_2 vi3_2_1_2) resistor r=50
VI4_2_1_2 (vs4_2_1_2 0) vsource dc=1.8 mag=0
RI4_2_1_2 (vs4_2_1_2 vi4_2_1_2) resistor r=50
VI5_2_1_2 (vs5_2_1_2 0) vsource dc=1.8 mag=0
RI5_2_1_2 (vs5_2_1_2 vi5_2_1_2) resistor r=50
VI6_2_1_2 (vs6_2_1_2 0) vsource dc=1.8 mag=0
RI6_2_1_2 (vs6_2_1_2 vi6_2_1_2) resistor r=50
VI7_2_1_2 (vs7_2_1_2 0) vsource dc=1.8 mag=0
RI7_2_1_2 (vs7_2_1_2 vi7_2_1_2) resistor r=50
X2_1_2 (vdd2_1_2 0 s2_2_1_2 s1_2_1_2 s0_2_1_2 vi7_2_1_2 vi6_2_1_2 vi5_2_1_2 vi4_2_1_2 vi3_2_1_2 vi2_2_1_2 vi1_2_1_2 vi0_2_1_2 vo2_1_2) input_mux_8to1
CL2_1_2 (vo2_1_2 0) capacitor c=1p
save vo2_1_2 VDD2_1_2:p
VDD2_1_3 (vdsrc2_1_3 0) vsource dc=1.8
RVD2_1_3 (vdsrc2_1_3 vdd2_1_3) resistor r=50
VS0_2_1_3 (ss0_2_1_3 0) vsource dc=1.8
RS0_2_1_3 (ss0_2_1_3 s0_2_1_3) resistor r=50
VS1_2_1_3 (ss1_2_1_3 0) vsource dc=0
RS1_2_1_3 (ss1_2_1_3 s1_2_1_3) resistor r=50
VS2_2_1_3 (ss2_2_1_3 0) vsource dc=0
RS2_2_1_3 (ss2_2_1_3 s2_2_1_3) resistor r=50
VI0_2_1_3 (vs0_2_1_3 0) vsource dc=1.8 mag=0
RI0_2_1_3 (vs0_2_1_3 vi0_2_1_3) resistor r=50
VI1_2_1_3 (vs1_2_1_3 0) vsource dc=1.8 mag=0
RI1_2_1_3 (vs1_2_1_3 vi1_2_1_3) resistor r=50
VI2_2_1_3 (vs2_2_1_3 0) vsource dc=1.8 mag=0
RI2_2_1_3 (vs2_2_1_3 vi2_2_1_3) resistor r=50
VI3_2_1_3 (vs3_2_1_3 0) vsource dc=1.8 mag=1
RI3_2_1_3 (vs3_2_1_3 vi3_2_1_3) resistor r=50
VI4_2_1_3 (vs4_2_1_3 0) vsource dc=1.8 mag=0
RI4_2_1_3 (vs4_2_1_3 vi4_2_1_3) resistor r=50
VI5_2_1_3 (vs5_2_1_3 0) vsource dc=1.8 mag=0
RI5_2_1_3 (vs5_2_1_3 vi5_2_1_3) resistor r=50
VI6_2_1_3 (vs6_2_1_3 0) vsource dc=1.8 mag=0
RI6_2_1_3 (vs6_2_1_3 vi6_2_1_3) resistor r=50
VI7_2_1_3 (vs7_2_1_3 0) vsource dc=1.8 mag=0
RI7_2_1_3 (vs7_2_1_3 vi7_2_1_3) resistor r=50
X2_1_3 (vdd2_1_3 0 s2_2_1_3 s1_2_1_3 s0_2_1_3 vi7_2_1_3 vi6_2_1_3 vi5_2_1_3 vi4_2_1_3 vi3_2_1_3 vi2_2_1_3 vi1_2_1_3 vi0_2_1_3 vo2_1_3) input_mux_8to1
CL2_1_3 (vo2_1_3 0) capacitor c=1p
save vo2_1_3 VDD2_1_3:p
VDD2_1_4 (vdsrc2_1_4 0) vsource dc=1.8
RVD2_1_4 (vdsrc2_1_4 vdd2_1_4) resistor r=50
VS0_2_1_4 (ss0_2_1_4 0) vsource dc=1.8
RS0_2_1_4 (ss0_2_1_4 s0_2_1_4) resistor r=50
VS1_2_1_4 (ss1_2_1_4 0) vsource dc=0
RS1_2_1_4 (ss1_2_1_4 s1_2_1_4) resistor r=50
VS2_2_1_4 (ss2_2_1_4 0) vsource dc=0
RS2_2_1_4 (ss2_2_1_4 s2_2_1_4) resistor r=50
VI0_2_1_4 (vs0_2_1_4 0) vsource dc=1.8 mag=0
RI0_2_1_4 (vs0_2_1_4 vi0_2_1_4) resistor r=50
VI1_2_1_4 (vs1_2_1_4 0) vsource dc=1.8 mag=0
RI1_2_1_4 (vs1_2_1_4 vi1_2_1_4) resistor r=50
VI2_2_1_4 (vs2_2_1_4 0) vsource dc=1.8 mag=0
RI2_2_1_4 (vs2_2_1_4 vi2_2_1_4) resistor r=50
VI3_2_1_4 (vs3_2_1_4 0) vsource dc=1.8 mag=0
RI3_2_1_4 (vs3_2_1_4 vi3_2_1_4) resistor r=50
VI4_2_1_4 (vs4_2_1_4 0) vsource dc=1.8 mag=1
RI4_2_1_4 (vs4_2_1_4 vi4_2_1_4) resistor r=50
VI5_2_1_4 (vs5_2_1_4 0) vsource dc=1.8 mag=0
RI5_2_1_4 (vs5_2_1_4 vi5_2_1_4) resistor r=50
VI6_2_1_4 (vs6_2_1_4 0) vsource dc=1.8 mag=0
RI6_2_1_4 (vs6_2_1_4 vi6_2_1_4) resistor r=50
VI7_2_1_4 (vs7_2_1_4 0) vsource dc=1.8 mag=0
RI7_2_1_4 (vs7_2_1_4 vi7_2_1_4) resistor r=50
X2_1_4 (vdd2_1_4 0 s2_2_1_4 s1_2_1_4 s0_2_1_4 vi7_2_1_4 vi6_2_1_4 vi5_2_1_4 vi4_2_1_4 vi3_2_1_4 vi2_2_1_4 vi1_2_1_4 vi0_2_1_4 vo2_1_4) input_mux_8to1
CL2_1_4 (vo2_1_4 0) capacitor c=1p
save vo2_1_4 VDD2_1_4:p
VDD2_1_5 (vdsrc2_1_5 0) vsource dc=1.8
RVD2_1_5 (vdsrc2_1_5 vdd2_1_5) resistor r=50
VS0_2_1_5 (ss0_2_1_5 0) vsource dc=1.8
RS0_2_1_5 (ss0_2_1_5 s0_2_1_5) resistor r=50
VS1_2_1_5 (ss1_2_1_5 0) vsource dc=0
RS1_2_1_5 (ss1_2_1_5 s1_2_1_5) resistor r=50
VS2_2_1_5 (ss2_2_1_5 0) vsource dc=0
RS2_2_1_5 (ss2_2_1_5 s2_2_1_5) resistor r=50
VI0_2_1_5 (vs0_2_1_5 0) vsource dc=1.8 mag=0
RI0_2_1_5 (vs0_2_1_5 vi0_2_1_5) resistor r=50
VI1_2_1_5 (vs1_2_1_5 0) vsource dc=1.8 mag=0
RI1_2_1_5 (vs1_2_1_5 vi1_2_1_5) resistor r=50
VI2_2_1_5 (vs2_2_1_5 0) vsource dc=1.8 mag=0
RI2_2_1_5 (vs2_2_1_5 vi2_2_1_5) resistor r=50
VI3_2_1_5 (vs3_2_1_5 0) vsource dc=1.8 mag=0
RI3_2_1_5 (vs3_2_1_5 vi3_2_1_5) resistor r=50
VI4_2_1_5 (vs4_2_1_5 0) vsource dc=1.8 mag=0
RI4_2_1_5 (vs4_2_1_5 vi4_2_1_5) resistor r=50
VI5_2_1_5 (vs5_2_1_5 0) vsource dc=1.8 mag=1
RI5_2_1_5 (vs5_2_1_5 vi5_2_1_5) resistor r=50
VI6_2_1_5 (vs6_2_1_5 0) vsource dc=1.8 mag=0
RI6_2_1_5 (vs6_2_1_5 vi6_2_1_5) resistor r=50
VI7_2_1_5 (vs7_2_1_5 0) vsource dc=1.8 mag=0
RI7_2_1_5 (vs7_2_1_5 vi7_2_1_5) resistor r=50
X2_1_5 (vdd2_1_5 0 s2_2_1_5 s1_2_1_5 s0_2_1_5 vi7_2_1_5 vi6_2_1_5 vi5_2_1_5 vi4_2_1_5 vi3_2_1_5 vi2_2_1_5 vi1_2_1_5 vi0_2_1_5 vo2_1_5) input_mux_8to1
CL2_1_5 (vo2_1_5 0) capacitor c=1p
save vo2_1_5 VDD2_1_5:p
VDD2_1_6 (vdsrc2_1_6 0) vsource dc=1.8
RVD2_1_6 (vdsrc2_1_6 vdd2_1_6) resistor r=50
VS0_2_1_6 (ss0_2_1_6 0) vsource dc=1.8
RS0_2_1_6 (ss0_2_1_6 s0_2_1_6) resistor r=50
VS1_2_1_6 (ss1_2_1_6 0) vsource dc=0
RS1_2_1_6 (ss1_2_1_6 s1_2_1_6) resistor r=50
VS2_2_1_6 (ss2_2_1_6 0) vsource dc=0
RS2_2_1_6 (ss2_2_1_6 s2_2_1_6) resistor r=50
VI0_2_1_6 (vs0_2_1_6 0) vsource dc=1.8 mag=0
RI0_2_1_6 (vs0_2_1_6 vi0_2_1_6) resistor r=50
VI1_2_1_6 (vs1_2_1_6 0) vsource dc=1.8 mag=0
RI1_2_1_6 (vs1_2_1_6 vi1_2_1_6) resistor r=50
VI2_2_1_6 (vs2_2_1_6 0) vsource dc=1.8 mag=0
RI2_2_1_6 (vs2_2_1_6 vi2_2_1_6) resistor r=50
VI3_2_1_6 (vs3_2_1_6 0) vsource dc=1.8 mag=0
RI3_2_1_6 (vs3_2_1_6 vi3_2_1_6) resistor r=50
VI4_2_1_6 (vs4_2_1_6 0) vsource dc=1.8 mag=0
RI4_2_1_6 (vs4_2_1_6 vi4_2_1_6) resistor r=50
VI5_2_1_6 (vs5_2_1_6 0) vsource dc=1.8 mag=0
RI5_2_1_6 (vs5_2_1_6 vi5_2_1_6) resistor r=50
VI6_2_1_6 (vs6_2_1_6 0) vsource dc=1.8 mag=1
RI6_2_1_6 (vs6_2_1_6 vi6_2_1_6) resistor r=50
VI7_2_1_6 (vs7_2_1_6 0) vsource dc=1.8 mag=0
RI7_2_1_6 (vs7_2_1_6 vi7_2_1_6) resistor r=50
X2_1_6 (vdd2_1_6 0 s2_2_1_6 s1_2_1_6 s0_2_1_6 vi7_2_1_6 vi6_2_1_6 vi5_2_1_6 vi4_2_1_6 vi3_2_1_6 vi2_2_1_6 vi1_2_1_6 vi0_2_1_6 vo2_1_6) input_mux_8to1
CL2_1_6 (vo2_1_6 0) capacitor c=1p
save vo2_1_6 VDD2_1_6:p
VDD2_1_7 (vdsrc2_1_7 0) vsource dc=1.8
RVD2_1_7 (vdsrc2_1_7 vdd2_1_7) resistor r=50
VS0_2_1_7 (ss0_2_1_7 0) vsource dc=1.8
RS0_2_1_7 (ss0_2_1_7 s0_2_1_7) resistor r=50
VS1_2_1_7 (ss1_2_1_7 0) vsource dc=0
RS1_2_1_7 (ss1_2_1_7 s1_2_1_7) resistor r=50
VS2_2_1_7 (ss2_2_1_7 0) vsource dc=0
RS2_2_1_7 (ss2_2_1_7 s2_2_1_7) resistor r=50
VI0_2_1_7 (vs0_2_1_7 0) vsource dc=1.8 mag=0
RI0_2_1_7 (vs0_2_1_7 vi0_2_1_7) resistor r=50
VI1_2_1_7 (vs1_2_1_7 0) vsource dc=1.8 mag=0
RI1_2_1_7 (vs1_2_1_7 vi1_2_1_7) resistor r=50
VI2_2_1_7 (vs2_2_1_7 0) vsource dc=1.8 mag=0
RI2_2_1_7 (vs2_2_1_7 vi2_2_1_7) resistor r=50
VI3_2_1_7 (vs3_2_1_7 0) vsource dc=1.8 mag=0
RI3_2_1_7 (vs3_2_1_7 vi3_2_1_7) resistor r=50
VI4_2_1_7 (vs4_2_1_7 0) vsource dc=1.8 mag=0
RI4_2_1_7 (vs4_2_1_7 vi4_2_1_7) resistor r=50
VI5_2_1_7 (vs5_2_1_7 0) vsource dc=1.8 mag=0
RI5_2_1_7 (vs5_2_1_7 vi5_2_1_7) resistor r=50
VI6_2_1_7 (vs6_2_1_7 0) vsource dc=1.8 mag=0
RI6_2_1_7 (vs6_2_1_7 vi6_2_1_7) resistor r=50
VI7_2_1_7 (vs7_2_1_7 0) vsource dc=1.8 mag=1
RI7_2_1_7 (vs7_2_1_7 vi7_2_1_7) resistor r=50
X2_1_7 (vdd2_1_7 0 s2_2_1_7 s1_2_1_7 s0_2_1_7 vi7_2_1_7 vi6_2_1_7 vi5_2_1_7 vi4_2_1_7 vi3_2_1_7 vi2_2_1_7 vi1_2_1_7 vi0_2_1_7 vo2_1_7) input_mux_8to1
CL2_1_7 (vo2_1_7 0) capacitor c=1p
save vo2_1_7 VDD2_1_7:p
VDD2_2_0 (vdsrc2_2_0 0) vsource dc=1.8
RVD2_2_0 (vdsrc2_2_0 vdd2_2_0) resistor r=50
VS0_2_2_0 (ss0_2_2_0 0) vsource dc=0
RS0_2_2_0 (ss0_2_2_0 s0_2_2_0) resistor r=50
VS1_2_2_0 (ss1_2_2_0 0) vsource dc=1.8
RS1_2_2_0 (ss1_2_2_0 s1_2_2_0) resistor r=50
VS2_2_2_0 (ss2_2_2_0 0) vsource dc=0
RS2_2_2_0 (ss2_2_2_0 s2_2_2_0) resistor r=50
VI0_2_2_0 (vs0_2_2_0 0) vsource dc=1.8 mag=1
RI0_2_2_0 (vs0_2_2_0 vi0_2_2_0) resistor r=50
VI1_2_2_0 (vs1_2_2_0 0) vsource dc=1.8 mag=0
RI1_2_2_0 (vs1_2_2_0 vi1_2_2_0) resistor r=50
VI2_2_2_0 (vs2_2_2_0 0) vsource dc=1.8 mag=0
RI2_2_2_0 (vs2_2_2_0 vi2_2_2_0) resistor r=50
VI3_2_2_0 (vs3_2_2_0 0) vsource dc=1.8 mag=0
RI3_2_2_0 (vs3_2_2_0 vi3_2_2_0) resistor r=50
VI4_2_2_0 (vs4_2_2_0 0) vsource dc=1.8 mag=0
RI4_2_2_0 (vs4_2_2_0 vi4_2_2_0) resistor r=50
VI5_2_2_0 (vs5_2_2_0 0) vsource dc=1.8 mag=0
RI5_2_2_0 (vs5_2_2_0 vi5_2_2_0) resistor r=50
VI6_2_2_0 (vs6_2_2_0 0) vsource dc=1.8 mag=0
RI6_2_2_0 (vs6_2_2_0 vi6_2_2_0) resistor r=50
VI7_2_2_0 (vs7_2_2_0 0) vsource dc=1.8 mag=0
RI7_2_2_0 (vs7_2_2_0 vi7_2_2_0) resistor r=50
X2_2_0 (vdd2_2_0 0 s2_2_2_0 s1_2_2_0 s0_2_2_0 vi7_2_2_0 vi6_2_2_0 vi5_2_2_0 vi4_2_2_0 vi3_2_2_0 vi2_2_2_0 vi1_2_2_0 vi0_2_2_0 vo2_2_0) input_mux_8to1
CL2_2_0 (vo2_2_0 0) capacitor c=1p
save vo2_2_0 VDD2_2_0:p
VDD2_2_1 (vdsrc2_2_1 0) vsource dc=1.8
RVD2_2_1 (vdsrc2_2_1 vdd2_2_1) resistor r=50
VS0_2_2_1 (ss0_2_2_1 0) vsource dc=0
RS0_2_2_1 (ss0_2_2_1 s0_2_2_1) resistor r=50
VS1_2_2_1 (ss1_2_2_1 0) vsource dc=1.8
RS1_2_2_1 (ss1_2_2_1 s1_2_2_1) resistor r=50
VS2_2_2_1 (ss2_2_2_1 0) vsource dc=0
RS2_2_2_1 (ss2_2_2_1 s2_2_2_1) resistor r=50
VI0_2_2_1 (vs0_2_2_1 0) vsource dc=1.8 mag=0
RI0_2_2_1 (vs0_2_2_1 vi0_2_2_1) resistor r=50
VI1_2_2_1 (vs1_2_2_1 0) vsource dc=1.8 mag=1
RI1_2_2_1 (vs1_2_2_1 vi1_2_2_1) resistor r=50
VI2_2_2_1 (vs2_2_2_1 0) vsource dc=1.8 mag=0
RI2_2_2_1 (vs2_2_2_1 vi2_2_2_1) resistor r=50
VI3_2_2_1 (vs3_2_2_1 0) vsource dc=1.8 mag=0
RI3_2_2_1 (vs3_2_2_1 vi3_2_2_1) resistor r=50
VI4_2_2_1 (vs4_2_2_1 0) vsource dc=1.8 mag=0
RI4_2_2_1 (vs4_2_2_1 vi4_2_2_1) resistor r=50
VI5_2_2_1 (vs5_2_2_1 0) vsource dc=1.8 mag=0
RI5_2_2_1 (vs5_2_2_1 vi5_2_2_1) resistor r=50
VI6_2_2_1 (vs6_2_2_1 0) vsource dc=1.8 mag=0
RI6_2_2_1 (vs6_2_2_1 vi6_2_2_1) resistor r=50
VI7_2_2_1 (vs7_2_2_1 0) vsource dc=1.8 mag=0
RI7_2_2_1 (vs7_2_2_1 vi7_2_2_1) resistor r=50
X2_2_1 (vdd2_2_1 0 s2_2_2_1 s1_2_2_1 s0_2_2_1 vi7_2_2_1 vi6_2_2_1 vi5_2_2_1 vi4_2_2_1 vi3_2_2_1 vi2_2_2_1 vi1_2_2_1 vi0_2_2_1 vo2_2_1) input_mux_8to1
CL2_2_1 (vo2_2_1 0) capacitor c=1p
save vo2_2_1 VDD2_2_1:p
VDD2_2_2 (vdsrc2_2_2 0) vsource dc=1.8
RVD2_2_2 (vdsrc2_2_2 vdd2_2_2) resistor r=50
VS0_2_2_2 (ss0_2_2_2 0) vsource dc=0
RS0_2_2_2 (ss0_2_2_2 s0_2_2_2) resistor r=50
VS1_2_2_2 (ss1_2_2_2 0) vsource dc=1.8
RS1_2_2_2 (ss1_2_2_2 s1_2_2_2) resistor r=50
VS2_2_2_2 (ss2_2_2_2 0) vsource dc=0
RS2_2_2_2 (ss2_2_2_2 s2_2_2_2) resistor r=50
VI0_2_2_2 (vs0_2_2_2 0) vsource dc=1.8 mag=0
RI0_2_2_2 (vs0_2_2_2 vi0_2_2_2) resistor r=50
VI1_2_2_2 (vs1_2_2_2 0) vsource dc=1.8 mag=0
RI1_2_2_2 (vs1_2_2_2 vi1_2_2_2) resistor r=50
VI2_2_2_2 (vs2_2_2_2 0) vsource dc=1.8 mag=1
RI2_2_2_2 (vs2_2_2_2 vi2_2_2_2) resistor r=50
VI3_2_2_2 (vs3_2_2_2 0) vsource dc=1.8 mag=0
RI3_2_2_2 (vs3_2_2_2 vi3_2_2_2) resistor r=50
VI4_2_2_2 (vs4_2_2_2 0) vsource dc=1.8 mag=0
RI4_2_2_2 (vs4_2_2_2 vi4_2_2_2) resistor r=50
VI5_2_2_2 (vs5_2_2_2 0) vsource dc=1.8 mag=0
RI5_2_2_2 (vs5_2_2_2 vi5_2_2_2) resistor r=50
VI6_2_2_2 (vs6_2_2_2 0) vsource dc=1.8 mag=0
RI6_2_2_2 (vs6_2_2_2 vi6_2_2_2) resistor r=50
VI7_2_2_2 (vs7_2_2_2 0) vsource dc=1.8 mag=0
RI7_2_2_2 (vs7_2_2_2 vi7_2_2_2) resistor r=50
X2_2_2 (vdd2_2_2 0 s2_2_2_2 s1_2_2_2 s0_2_2_2 vi7_2_2_2 vi6_2_2_2 vi5_2_2_2 vi4_2_2_2 vi3_2_2_2 vi2_2_2_2 vi1_2_2_2 vi0_2_2_2 vo2_2_2) input_mux_8to1
CL2_2_2 (vo2_2_2 0) capacitor c=1p
save vo2_2_2 VDD2_2_2:p
VDD2_2_3 (vdsrc2_2_3 0) vsource dc=1.8
RVD2_2_3 (vdsrc2_2_3 vdd2_2_3) resistor r=50
VS0_2_2_3 (ss0_2_2_3 0) vsource dc=0
RS0_2_2_3 (ss0_2_2_3 s0_2_2_3) resistor r=50
VS1_2_2_3 (ss1_2_2_3 0) vsource dc=1.8
RS1_2_2_3 (ss1_2_2_3 s1_2_2_3) resistor r=50
VS2_2_2_3 (ss2_2_2_3 0) vsource dc=0
RS2_2_2_3 (ss2_2_2_3 s2_2_2_3) resistor r=50
VI0_2_2_3 (vs0_2_2_3 0) vsource dc=1.8 mag=0
RI0_2_2_3 (vs0_2_2_3 vi0_2_2_3) resistor r=50
VI1_2_2_3 (vs1_2_2_3 0) vsource dc=1.8 mag=0
RI1_2_2_3 (vs1_2_2_3 vi1_2_2_3) resistor r=50
VI2_2_2_3 (vs2_2_2_3 0) vsource dc=1.8 mag=0
RI2_2_2_3 (vs2_2_2_3 vi2_2_2_3) resistor r=50
VI3_2_2_3 (vs3_2_2_3 0) vsource dc=1.8 mag=1
RI3_2_2_3 (vs3_2_2_3 vi3_2_2_3) resistor r=50
VI4_2_2_3 (vs4_2_2_3 0) vsource dc=1.8 mag=0
RI4_2_2_3 (vs4_2_2_3 vi4_2_2_3) resistor r=50
VI5_2_2_3 (vs5_2_2_3 0) vsource dc=1.8 mag=0
RI5_2_2_3 (vs5_2_2_3 vi5_2_2_3) resistor r=50
VI6_2_2_3 (vs6_2_2_3 0) vsource dc=1.8 mag=0
RI6_2_2_3 (vs6_2_2_3 vi6_2_2_3) resistor r=50
VI7_2_2_3 (vs7_2_2_3 0) vsource dc=1.8 mag=0
RI7_2_2_3 (vs7_2_2_3 vi7_2_2_3) resistor r=50
X2_2_3 (vdd2_2_3 0 s2_2_2_3 s1_2_2_3 s0_2_2_3 vi7_2_2_3 vi6_2_2_3 vi5_2_2_3 vi4_2_2_3 vi3_2_2_3 vi2_2_2_3 vi1_2_2_3 vi0_2_2_3 vo2_2_3) input_mux_8to1
CL2_2_3 (vo2_2_3 0) capacitor c=1p
save vo2_2_3 VDD2_2_3:p
VDD2_2_4 (vdsrc2_2_4 0) vsource dc=1.8
RVD2_2_4 (vdsrc2_2_4 vdd2_2_4) resistor r=50
VS0_2_2_4 (ss0_2_2_4 0) vsource dc=0
RS0_2_2_4 (ss0_2_2_4 s0_2_2_4) resistor r=50
VS1_2_2_4 (ss1_2_2_4 0) vsource dc=1.8
RS1_2_2_4 (ss1_2_2_4 s1_2_2_4) resistor r=50
VS2_2_2_4 (ss2_2_2_4 0) vsource dc=0
RS2_2_2_4 (ss2_2_2_4 s2_2_2_4) resistor r=50
VI0_2_2_4 (vs0_2_2_4 0) vsource dc=1.8 mag=0
RI0_2_2_4 (vs0_2_2_4 vi0_2_2_4) resistor r=50
VI1_2_2_4 (vs1_2_2_4 0) vsource dc=1.8 mag=0
RI1_2_2_4 (vs1_2_2_4 vi1_2_2_4) resistor r=50
VI2_2_2_4 (vs2_2_2_4 0) vsource dc=1.8 mag=0
RI2_2_2_4 (vs2_2_2_4 vi2_2_2_4) resistor r=50
VI3_2_2_4 (vs3_2_2_4 0) vsource dc=1.8 mag=0
RI3_2_2_4 (vs3_2_2_4 vi3_2_2_4) resistor r=50
VI4_2_2_4 (vs4_2_2_4 0) vsource dc=1.8 mag=1
RI4_2_2_4 (vs4_2_2_4 vi4_2_2_4) resistor r=50
VI5_2_2_4 (vs5_2_2_4 0) vsource dc=1.8 mag=0
RI5_2_2_4 (vs5_2_2_4 vi5_2_2_4) resistor r=50
VI6_2_2_4 (vs6_2_2_4 0) vsource dc=1.8 mag=0
RI6_2_2_4 (vs6_2_2_4 vi6_2_2_4) resistor r=50
VI7_2_2_4 (vs7_2_2_4 0) vsource dc=1.8 mag=0
RI7_2_2_4 (vs7_2_2_4 vi7_2_2_4) resistor r=50
X2_2_4 (vdd2_2_4 0 s2_2_2_4 s1_2_2_4 s0_2_2_4 vi7_2_2_4 vi6_2_2_4 vi5_2_2_4 vi4_2_2_4 vi3_2_2_4 vi2_2_2_4 vi1_2_2_4 vi0_2_2_4 vo2_2_4) input_mux_8to1
CL2_2_4 (vo2_2_4 0) capacitor c=1p
save vo2_2_4 VDD2_2_4:p
VDD2_2_5 (vdsrc2_2_5 0) vsource dc=1.8
RVD2_2_5 (vdsrc2_2_5 vdd2_2_5) resistor r=50
VS0_2_2_5 (ss0_2_2_5 0) vsource dc=0
RS0_2_2_5 (ss0_2_2_5 s0_2_2_5) resistor r=50
VS1_2_2_5 (ss1_2_2_5 0) vsource dc=1.8
RS1_2_2_5 (ss1_2_2_5 s1_2_2_5) resistor r=50
VS2_2_2_5 (ss2_2_2_5 0) vsource dc=0
RS2_2_2_5 (ss2_2_2_5 s2_2_2_5) resistor r=50
VI0_2_2_5 (vs0_2_2_5 0) vsource dc=1.8 mag=0
RI0_2_2_5 (vs0_2_2_5 vi0_2_2_5) resistor r=50
VI1_2_2_5 (vs1_2_2_5 0) vsource dc=1.8 mag=0
RI1_2_2_5 (vs1_2_2_5 vi1_2_2_5) resistor r=50
VI2_2_2_5 (vs2_2_2_5 0) vsource dc=1.8 mag=0
RI2_2_2_5 (vs2_2_2_5 vi2_2_2_5) resistor r=50
VI3_2_2_5 (vs3_2_2_5 0) vsource dc=1.8 mag=0
RI3_2_2_5 (vs3_2_2_5 vi3_2_2_5) resistor r=50
VI4_2_2_5 (vs4_2_2_5 0) vsource dc=1.8 mag=0
RI4_2_2_5 (vs4_2_2_5 vi4_2_2_5) resistor r=50
VI5_2_2_5 (vs5_2_2_5 0) vsource dc=1.8 mag=1
RI5_2_2_5 (vs5_2_2_5 vi5_2_2_5) resistor r=50
VI6_2_2_5 (vs6_2_2_5 0) vsource dc=1.8 mag=0
RI6_2_2_5 (vs6_2_2_5 vi6_2_2_5) resistor r=50
VI7_2_2_5 (vs7_2_2_5 0) vsource dc=1.8 mag=0
RI7_2_2_5 (vs7_2_2_5 vi7_2_2_5) resistor r=50
X2_2_5 (vdd2_2_5 0 s2_2_2_5 s1_2_2_5 s0_2_2_5 vi7_2_2_5 vi6_2_2_5 vi5_2_2_5 vi4_2_2_5 vi3_2_2_5 vi2_2_2_5 vi1_2_2_5 vi0_2_2_5 vo2_2_5) input_mux_8to1
CL2_2_5 (vo2_2_5 0) capacitor c=1p
save vo2_2_5 VDD2_2_5:p
VDD2_2_6 (vdsrc2_2_6 0) vsource dc=1.8
RVD2_2_6 (vdsrc2_2_6 vdd2_2_6) resistor r=50
VS0_2_2_6 (ss0_2_2_6 0) vsource dc=0
RS0_2_2_6 (ss0_2_2_6 s0_2_2_6) resistor r=50
VS1_2_2_6 (ss1_2_2_6 0) vsource dc=1.8
RS1_2_2_6 (ss1_2_2_6 s1_2_2_6) resistor r=50
VS2_2_2_6 (ss2_2_2_6 0) vsource dc=0
RS2_2_2_6 (ss2_2_2_6 s2_2_2_6) resistor r=50
VI0_2_2_6 (vs0_2_2_6 0) vsource dc=1.8 mag=0
RI0_2_2_6 (vs0_2_2_6 vi0_2_2_6) resistor r=50
VI1_2_2_6 (vs1_2_2_6 0) vsource dc=1.8 mag=0
RI1_2_2_6 (vs1_2_2_6 vi1_2_2_6) resistor r=50
VI2_2_2_6 (vs2_2_2_6 0) vsource dc=1.8 mag=0
RI2_2_2_6 (vs2_2_2_6 vi2_2_2_6) resistor r=50
VI3_2_2_6 (vs3_2_2_6 0) vsource dc=1.8 mag=0
RI3_2_2_6 (vs3_2_2_6 vi3_2_2_6) resistor r=50
VI4_2_2_6 (vs4_2_2_6 0) vsource dc=1.8 mag=0
RI4_2_2_6 (vs4_2_2_6 vi4_2_2_6) resistor r=50
VI5_2_2_6 (vs5_2_2_6 0) vsource dc=1.8 mag=0
RI5_2_2_6 (vs5_2_2_6 vi5_2_2_6) resistor r=50
VI6_2_2_6 (vs6_2_2_6 0) vsource dc=1.8 mag=1
RI6_2_2_6 (vs6_2_2_6 vi6_2_2_6) resistor r=50
VI7_2_2_6 (vs7_2_2_6 0) vsource dc=1.8 mag=0
RI7_2_2_6 (vs7_2_2_6 vi7_2_2_6) resistor r=50
X2_2_6 (vdd2_2_6 0 s2_2_2_6 s1_2_2_6 s0_2_2_6 vi7_2_2_6 vi6_2_2_6 vi5_2_2_6 vi4_2_2_6 vi3_2_2_6 vi2_2_2_6 vi1_2_2_6 vi0_2_2_6 vo2_2_6) input_mux_8to1
CL2_2_6 (vo2_2_6 0) capacitor c=1p
save vo2_2_6 VDD2_2_6:p
VDD2_2_7 (vdsrc2_2_7 0) vsource dc=1.8
RVD2_2_7 (vdsrc2_2_7 vdd2_2_7) resistor r=50
VS0_2_2_7 (ss0_2_2_7 0) vsource dc=0
RS0_2_2_7 (ss0_2_2_7 s0_2_2_7) resistor r=50
VS1_2_2_7 (ss1_2_2_7 0) vsource dc=1.8
RS1_2_2_7 (ss1_2_2_7 s1_2_2_7) resistor r=50
VS2_2_2_7 (ss2_2_2_7 0) vsource dc=0
RS2_2_2_7 (ss2_2_2_7 s2_2_2_7) resistor r=50
VI0_2_2_7 (vs0_2_2_7 0) vsource dc=1.8 mag=0
RI0_2_2_7 (vs0_2_2_7 vi0_2_2_7) resistor r=50
VI1_2_2_7 (vs1_2_2_7 0) vsource dc=1.8 mag=0
RI1_2_2_7 (vs1_2_2_7 vi1_2_2_7) resistor r=50
VI2_2_2_7 (vs2_2_2_7 0) vsource dc=1.8 mag=0
RI2_2_2_7 (vs2_2_2_7 vi2_2_2_7) resistor r=50
VI3_2_2_7 (vs3_2_2_7 0) vsource dc=1.8 mag=0
RI3_2_2_7 (vs3_2_2_7 vi3_2_2_7) resistor r=50
VI4_2_2_7 (vs4_2_2_7 0) vsource dc=1.8 mag=0
RI4_2_2_7 (vs4_2_2_7 vi4_2_2_7) resistor r=50
VI5_2_2_7 (vs5_2_2_7 0) vsource dc=1.8 mag=0
RI5_2_2_7 (vs5_2_2_7 vi5_2_2_7) resistor r=50
VI6_2_2_7 (vs6_2_2_7 0) vsource dc=1.8 mag=0
RI6_2_2_7 (vs6_2_2_7 vi6_2_2_7) resistor r=50
VI7_2_2_7 (vs7_2_2_7 0) vsource dc=1.8 mag=1
RI7_2_2_7 (vs7_2_2_7 vi7_2_2_7) resistor r=50
X2_2_7 (vdd2_2_7 0 s2_2_2_7 s1_2_2_7 s0_2_2_7 vi7_2_2_7 vi6_2_2_7 vi5_2_2_7 vi4_2_2_7 vi3_2_2_7 vi2_2_2_7 vi1_2_2_7 vi0_2_2_7 vo2_2_7) input_mux_8to1
CL2_2_7 (vo2_2_7 0) capacitor c=1p
save vo2_2_7 VDD2_2_7:p
VDD2_3_0 (vdsrc2_3_0 0) vsource dc=1.8
RVD2_3_0 (vdsrc2_3_0 vdd2_3_0) resistor r=50
VS0_2_3_0 (ss0_2_3_0 0) vsource dc=1.8
RS0_2_3_0 (ss0_2_3_0 s0_2_3_0) resistor r=50
VS1_2_3_0 (ss1_2_3_0 0) vsource dc=1.8
RS1_2_3_0 (ss1_2_3_0 s1_2_3_0) resistor r=50
VS2_2_3_0 (ss2_2_3_0 0) vsource dc=0
RS2_2_3_0 (ss2_2_3_0 s2_2_3_0) resistor r=50
VI0_2_3_0 (vs0_2_3_0 0) vsource dc=1.8 mag=1
RI0_2_3_0 (vs0_2_3_0 vi0_2_3_0) resistor r=50
VI1_2_3_0 (vs1_2_3_0 0) vsource dc=1.8 mag=0
RI1_2_3_0 (vs1_2_3_0 vi1_2_3_0) resistor r=50
VI2_2_3_0 (vs2_2_3_0 0) vsource dc=1.8 mag=0
RI2_2_3_0 (vs2_2_3_0 vi2_2_3_0) resistor r=50
VI3_2_3_0 (vs3_2_3_0 0) vsource dc=1.8 mag=0
RI3_2_3_0 (vs3_2_3_0 vi3_2_3_0) resistor r=50
VI4_2_3_0 (vs4_2_3_0 0) vsource dc=1.8 mag=0
RI4_2_3_0 (vs4_2_3_0 vi4_2_3_0) resistor r=50
VI5_2_3_0 (vs5_2_3_0 0) vsource dc=1.8 mag=0
RI5_2_3_0 (vs5_2_3_0 vi5_2_3_0) resistor r=50
VI6_2_3_0 (vs6_2_3_0 0) vsource dc=1.8 mag=0
RI6_2_3_0 (vs6_2_3_0 vi6_2_3_0) resistor r=50
VI7_2_3_0 (vs7_2_3_0 0) vsource dc=1.8 mag=0
RI7_2_3_0 (vs7_2_3_0 vi7_2_3_0) resistor r=50
X2_3_0 (vdd2_3_0 0 s2_2_3_0 s1_2_3_0 s0_2_3_0 vi7_2_3_0 vi6_2_3_0 vi5_2_3_0 vi4_2_3_0 vi3_2_3_0 vi2_2_3_0 vi1_2_3_0 vi0_2_3_0 vo2_3_0) input_mux_8to1
CL2_3_0 (vo2_3_0 0) capacitor c=1p
save vo2_3_0 VDD2_3_0:p
VDD2_3_1 (vdsrc2_3_1 0) vsource dc=1.8
RVD2_3_1 (vdsrc2_3_1 vdd2_3_1) resistor r=50
VS0_2_3_1 (ss0_2_3_1 0) vsource dc=1.8
RS0_2_3_1 (ss0_2_3_1 s0_2_3_1) resistor r=50
VS1_2_3_1 (ss1_2_3_1 0) vsource dc=1.8
RS1_2_3_1 (ss1_2_3_1 s1_2_3_1) resistor r=50
VS2_2_3_1 (ss2_2_3_1 0) vsource dc=0
RS2_2_3_1 (ss2_2_3_1 s2_2_3_1) resistor r=50
VI0_2_3_1 (vs0_2_3_1 0) vsource dc=1.8 mag=0
RI0_2_3_1 (vs0_2_3_1 vi0_2_3_1) resistor r=50
VI1_2_3_1 (vs1_2_3_1 0) vsource dc=1.8 mag=1
RI1_2_3_1 (vs1_2_3_1 vi1_2_3_1) resistor r=50
VI2_2_3_1 (vs2_2_3_1 0) vsource dc=1.8 mag=0
RI2_2_3_1 (vs2_2_3_1 vi2_2_3_1) resistor r=50
VI3_2_3_1 (vs3_2_3_1 0) vsource dc=1.8 mag=0
RI3_2_3_1 (vs3_2_3_1 vi3_2_3_1) resistor r=50
VI4_2_3_1 (vs4_2_3_1 0) vsource dc=1.8 mag=0
RI4_2_3_1 (vs4_2_3_1 vi4_2_3_1) resistor r=50
VI5_2_3_1 (vs5_2_3_1 0) vsource dc=1.8 mag=0
RI5_2_3_1 (vs5_2_3_1 vi5_2_3_1) resistor r=50
VI6_2_3_1 (vs6_2_3_1 0) vsource dc=1.8 mag=0
RI6_2_3_1 (vs6_2_3_1 vi6_2_3_1) resistor r=50
VI7_2_3_1 (vs7_2_3_1 0) vsource dc=1.8 mag=0
RI7_2_3_1 (vs7_2_3_1 vi7_2_3_1) resistor r=50
X2_3_1 (vdd2_3_1 0 s2_2_3_1 s1_2_3_1 s0_2_3_1 vi7_2_3_1 vi6_2_3_1 vi5_2_3_1 vi4_2_3_1 vi3_2_3_1 vi2_2_3_1 vi1_2_3_1 vi0_2_3_1 vo2_3_1) input_mux_8to1
CL2_3_1 (vo2_3_1 0) capacitor c=1p
save vo2_3_1 VDD2_3_1:p
VDD2_3_2 (vdsrc2_3_2 0) vsource dc=1.8
RVD2_3_2 (vdsrc2_3_2 vdd2_3_2) resistor r=50
VS0_2_3_2 (ss0_2_3_2 0) vsource dc=1.8
RS0_2_3_2 (ss0_2_3_2 s0_2_3_2) resistor r=50
VS1_2_3_2 (ss1_2_3_2 0) vsource dc=1.8
RS1_2_3_2 (ss1_2_3_2 s1_2_3_2) resistor r=50
VS2_2_3_2 (ss2_2_3_2 0) vsource dc=0
RS2_2_3_2 (ss2_2_3_2 s2_2_3_2) resistor r=50
VI0_2_3_2 (vs0_2_3_2 0) vsource dc=1.8 mag=0
RI0_2_3_2 (vs0_2_3_2 vi0_2_3_2) resistor r=50
VI1_2_3_2 (vs1_2_3_2 0) vsource dc=1.8 mag=0
RI1_2_3_2 (vs1_2_3_2 vi1_2_3_2) resistor r=50
VI2_2_3_2 (vs2_2_3_2 0) vsource dc=1.8 mag=1
RI2_2_3_2 (vs2_2_3_2 vi2_2_3_2) resistor r=50
VI3_2_3_2 (vs3_2_3_2 0) vsource dc=1.8 mag=0
RI3_2_3_2 (vs3_2_3_2 vi3_2_3_2) resistor r=50
VI4_2_3_2 (vs4_2_3_2 0) vsource dc=1.8 mag=0
RI4_2_3_2 (vs4_2_3_2 vi4_2_3_2) resistor r=50
VI5_2_3_2 (vs5_2_3_2 0) vsource dc=1.8 mag=0
RI5_2_3_2 (vs5_2_3_2 vi5_2_3_2) resistor r=50
VI6_2_3_2 (vs6_2_3_2 0) vsource dc=1.8 mag=0
RI6_2_3_2 (vs6_2_3_2 vi6_2_3_2) resistor r=50
VI7_2_3_2 (vs7_2_3_2 0) vsource dc=1.8 mag=0
RI7_2_3_2 (vs7_2_3_2 vi7_2_3_2) resistor r=50
X2_3_2 (vdd2_3_2 0 s2_2_3_2 s1_2_3_2 s0_2_3_2 vi7_2_3_2 vi6_2_3_2 vi5_2_3_2 vi4_2_3_2 vi3_2_3_2 vi2_2_3_2 vi1_2_3_2 vi0_2_3_2 vo2_3_2) input_mux_8to1
CL2_3_2 (vo2_3_2 0) capacitor c=1p
save vo2_3_2 VDD2_3_2:p
VDD2_3_3 (vdsrc2_3_3 0) vsource dc=1.8
RVD2_3_3 (vdsrc2_3_3 vdd2_3_3) resistor r=50
VS0_2_3_3 (ss0_2_3_3 0) vsource dc=1.8
RS0_2_3_3 (ss0_2_3_3 s0_2_3_3) resistor r=50
VS1_2_3_3 (ss1_2_3_3 0) vsource dc=1.8
RS1_2_3_3 (ss1_2_3_3 s1_2_3_3) resistor r=50
VS2_2_3_3 (ss2_2_3_3 0) vsource dc=0
RS2_2_3_3 (ss2_2_3_3 s2_2_3_3) resistor r=50
VI0_2_3_3 (vs0_2_3_3 0) vsource dc=1.8 mag=0
RI0_2_3_3 (vs0_2_3_3 vi0_2_3_3) resistor r=50
VI1_2_3_3 (vs1_2_3_3 0) vsource dc=1.8 mag=0
RI1_2_3_3 (vs1_2_3_3 vi1_2_3_3) resistor r=50
VI2_2_3_3 (vs2_2_3_3 0) vsource dc=1.8 mag=0
RI2_2_3_3 (vs2_2_3_3 vi2_2_3_3) resistor r=50
VI3_2_3_3 (vs3_2_3_3 0) vsource dc=1.8 mag=1
RI3_2_3_3 (vs3_2_3_3 vi3_2_3_3) resistor r=50
VI4_2_3_3 (vs4_2_3_3 0) vsource dc=1.8 mag=0
RI4_2_3_3 (vs4_2_3_3 vi4_2_3_3) resistor r=50
VI5_2_3_3 (vs5_2_3_3 0) vsource dc=1.8 mag=0
RI5_2_3_3 (vs5_2_3_3 vi5_2_3_3) resistor r=50
VI6_2_3_3 (vs6_2_3_3 0) vsource dc=1.8 mag=0
RI6_2_3_3 (vs6_2_3_3 vi6_2_3_3) resistor r=50
VI7_2_3_3 (vs7_2_3_3 0) vsource dc=1.8 mag=0
RI7_2_3_3 (vs7_2_3_3 vi7_2_3_3) resistor r=50
X2_3_3 (vdd2_3_3 0 s2_2_3_3 s1_2_3_3 s0_2_3_3 vi7_2_3_3 vi6_2_3_3 vi5_2_3_3 vi4_2_3_3 vi3_2_3_3 vi2_2_3_3 vi1_2_3_3 vi0_2_3_3 vo2_3_3) input_mux_8to1
CL2_3_3 (vo2_3_3 0) capacitor c=1p
save vo2_3_3 VDD2_3_3:p
VDD2_3_4 (vdsrc2_3_4 0) vsource dc=1.8
RVD2_3_4 (vdsrc2_3_4 vdd2_3_4) resistor r=50
VS0_2_3_4 (ss0_2_3_4 0) vsource dc=1.8
RS0_2_3_4 (ss0_2_3_4 s0_2_3_4) resistor r=50
VS1_2_3_4 (ss1_2_3_4 0) vsource dc=1.8
RS1_2_3_4 (ss1_2_3_4 s1_2_3_4) resistor r=50
VS2_2_3_4 (ss2_2_3_4 0) vsource dc=0
RS2_2_3_4 (ss2_2_3_4 s2_2_3_4) resistor r=50
VI0_2_3_4 (vs0_2_3_4 0) vsource dc=1.8 mag=0
RI0_2_3_4 (vs0_2_3_4 vi0_2_3_4) resistor r=50
VI1_2_3_4 (vs1_2_3_4 0) vsource dc=1.8 mag=0
RI1_2_3_4 (vs1_2_3_4 vi1_2_3_4) resistor r=50
VI2_2_3_4 (vs2_2_3_4 0) vsource dc=1.8 mag=0
RI2_2_3_4 (vs2_2_3_4 vi2_2_3_4) resistor r=50
VI3_2_3_4 (vs3_2_3_4 0) vsource dc=1.8 mag=0
RI3_2_3_4 (vs3_2_3_4 vi3_2_3_4) resistor r=50
VI4_2_3_4 (vs4_2_3_4 0) vsource dc=1.8 mag=1
RI4_2_3_4 (vs4_2_3_4 vi4_2_3_4) resistor r=50
VI5_2_3_4 (vs5_2_3_4 0) vsource dc=1.8 mag=0
RI5_2_3_4 (vs5_2_3_4 vi5_2_3_4) resistor r=50
VI6_2_3_4 (vs6_2_3_4 0) vsource dc=1.8 mag=0
RI6_2_3_4 (vs6_2_3_4 vi6_2_3_4) resistor r=50
VI7_2_3_4 (vs7_2_3_4 0) vsource dc=1.8 mag=0
RI7_2_3_4 (vs7_2_3_4 vi7_2_3_4) resistor r=50
X2_3_4 (vdd2_3_4 0 s2_2_3_4 s1_2_3_4 s0_2_3_4 vi7_2_3_4 vi6_2_3_4 vi5_2_3_4 vi4_2_3_4 vi3_2_3_4 vi2_2_3_4 vi1_2_3_4 vi0_2_3_4 vo2_3_4) input_mux_8to1
CL2_3_4 (vo2_3_4 0) capacitor c=1p
save vo2_3_4 VDD2_3_4:p
VDD2_3_5 (vdsrc2_3_5 0) vsource dc=1.8
RVD2_3_5 (vdsrc2_3_5 vdd2_3_5) resistor r=50
VS0_2_3_5 (ss0_2_3_5 0) vsource dc=1.8
RS0_2_3_5 (ss0_2_3_5 s0_2_3_5) resistor r=50
VS1_2_3_5 (ss1_2_3_5 0) vsource dc=1.8
RS1_2_3_5 (ss1_2_3_5 s1_2_3_5) resistor r=50
VS2_2_3_5 (ss2_2_3_5 0) vsource dc=0
RS2_2_3_5 (ss2_2_3_5 s2_2_3_5) resistor r=50
VI0_2_3_5 (vs0_2_3_5 0) vsource dc=1.8 mag=0
RI0_2_3_5 (vs0_2_3_5 vi0_2_3_5) resistor r=50
VI1_2_3_5 (vs1_2_3_5 0) vsource dc=1.8 mag=0
RI1_2_3_5 (vs1_2_3_5 vi1_2_3_5) resistor r=50
VI2_2_3_5 (vs2_2_3_5 0) vsource dc=1.8 mag=0
RI2_2_3_5 (vs2_2_3_5 vi2_2_3_5) resistor r=50
VI3_2_3_5 (vs3_2_3_5 0) vsource dc=1.8 mag=0
RI3_2_3_5 (vs3_2_3_5 vi3_2_3_5) resistor r=50
VI4_2_3_5 (vs4_2_3_5 0) vsource dc=1.8 mag=0
RI4_2_3_5 (vs4_2_3_5 vi4_2_3_5) resistor r=50
VI5_2_3_5 (vs5_2_3_5 0) vsource dc=1.8 mag=1
RI5_2_3_5 (vs5_2_3_5 vi5_2_3_5) resistor r=50
VI6_2_3_5 (vs6_2_3_5 0) vsource dc=1.8 mag=0
RI6_2_3_5 (vs6_2_3_5 vi6_2_3_5) resistor r=50
VI7_2_3_5 (vs7_2_3_5 0) vsource dc=1.8 mag=0
RI7_2_3_5 (vs7_2_3_5 vi7_2_3_5) resistor r=50
X2_3_5 (vdd2_3_5 0 s2_2_3_5 s1_2_3_5 s0_2_3_5 vi7_2_3_5 vi6_2_3_5 vi5_2_3_5 vi4_2_3_5 vi3_2_3_5 vi2_2_3_5 vi1_2_3_5 vi0_2_3_5 vo2_3_5) input_mux_8to1
CL2_3_5 (vo2_3_5 0) capacitor c=1p
save vo2_3_5 VDD2_3_5:p
VDD2_3_6 (vdsrc2_3_6 0) vsource dc=1.8
RVD2_3_6 (vdsrc2_3_6 vdd2_3_6) resistor r=50
VS0_2_3_6 (ss0_2_3_6 0) vsource dc=1.8
RS0_2_3_6 (ss0_2_3_6 s0_2_3_6) resistor r=50
VS1_2_3_6 (ss1_2_3_6 0) vsource dc=1.8
RS1_2_3_6 (ss1_2_3_6 s1_2_3_6) resistor r=50
VS2_2_3_6 (ss2_2_3_6 0) vsource dc=0
RS2_2_3_6 (ss2_2_3_6 s2_2_3_6) resistor r=50
VI0_2_3_6 (vs0_2_3_6 0) vsource dc=1.8 mag=0
RI0_2_3_6 (vs0_2_3_6 vi0_2_3_6) resistor r=50
VI1_2_3_6 (vs1_2_3_6 0) vsource dc=1.8 mag=0
RI1_2_3_6 (vs1_2_3_6 vi1_2_3_6) resistor r=50
VI2_2_3_6 (vs2_2_3_6 0) vsource dc=1.8 mag=0
RI2_2_3_6 (vs2_2_3_6 vi2_2_3_6) resistor r=50
VI3_2_3_6 (vs3_2_3_6 0) vsource dc=1.8 mag=0
RI3_2_3_6 (vs3_2_3_6 vi3_2_3_6) resistor r=50
VI4_2_3_6 (vs4_2_3_6 0) vsource dc=1.8 mag=0
RI4_2_3_6 (vs4_2_3_6 vi4_2_3_6) resistor r=50
VI5_2_3_6 (vs5_2_3_6 0) vsource dc=1.8 mag=0
RI5_2_3_6 (vs5_2_3_6 vi5_2_3_6) resistor r=50
VI6_2_3_6 (vs6_2_3_6 0) vsource dc=1.8 mag=1
RI6_2_3_6 (vs6_2_3_6 vi6_2_3_6) resistor r=50
VI7_2_3_6 (vs7_2_3_6 0) vsource dc=1.8 mag=0
RI7_2_3_6 (vs7_2_3_6 vi7_2_3_6) resistor r=50
X2_3_6 (vdd2_3_6 0 s2_2_3_6 s1_2_3_6 s0_2_3_6 vi7_2_3_6 vi6_2_3_6 vi5_2_3_6 vi4_2_3_6 vi3_2_3_6 vi2_2_3_6 vi1_2_3_6 vi0_2_3_6 vo2_3_6) input_mux_8to1
CL2_3_6 (vo2_3_6 0) capacitor c=1p
save vo2_3_6 VDD2_3_6:p
VDD2_3_7 (vdsrc2_3_7 0) vsource dc=1.8
RVD2_3_7 (vdsrc2_3_7 vdd2_3_7) resistor r=50
VS0_2_3_7 (ss0_2_3_7 0) vsource dc=1.8
RS0_2_3_7 (ss0_2_3_7 s0_2_3_7) resistor r=50
VS1_2_3_7 (ss1_2_3_7 0) vsource dc=1.8
RS1_2_3_7 (ss1_2_3_7 s1_2_3_7) resistor r=50
VS2_2_3_7 (ss2_2_3_7 0) vsource dc=0
RS2_2_3_7 (ss2_2_3_7 s2_2_3_7) resistor r=50
VI0_2_3_7 (vs0_2_3_7 0) vsource dc=1.8 mag=0
RI0_2_3_7 (vs0_2_3_7 vi0_2_3_7) resistor r=50
VI1_2_3_7 (vs1_2_3_7 0) vsource dc=1.8 mag=0
RI1_2_3_7 (vs1_2_3_7 vi1_2_3_7) resistor r=50
VI2_2_3_7 (vs2_2_3_7 0) vsource dc=1.8 mag=0
RI2_2_3_7 (vs2_2_3_7 vi2_2_3_7) resistor r=50
VI3_2_3_7 (vs3_2_3_7 0) vsource dc=1.8 mag=0
RI3_2_3_7 (vs3_2_3_7 vi3_2_3_7) resistor r=50
VI4_2_3_7 (vs4_2_3_7 0) vsource dc=1.8 mag=0
RI4_2_3_7 (vs4_2_3_7 vi4_2_3_7) resistor r=50
VI5_2_3_7 (vs5_2_3_7 0) vsource dc=1.8 mag=0
RI5_2_3_7 (vs5_2_3_7 vi5_2_3_7) resistor r=50
VI6_2_3_7 (vs6_2_3_7 0) vsource dc=1.8 mag=0
RI6_2_3_7 (vs6_2_3_7 vi6_2_3_7) resistor r=50
VI7_2_3_7 (vs7_2_3_7 0) vsource dc=1.8 mag=1
RI7_2_3_7 (vs7_2_3_7 vi7_2_3_7) resistor r=50
X2_3_7 (vdd2_3_7 0 s2_2_3_7 s1_2_3_7 s0_2_3_7 vi7_2_3_7 vi6_2_3_7 vi5_2_3_7 vi4_2_3_7 vi3_2_3_7 vi2_2_3_7 vi1_2_3_7 vi0_2_3_7 vo2_3_7) input_mux_8to1
CL2_3_7 (vo2_3_7 0) capacitor c=1p
save vo2_3_7 VDD2_3_7:p
VDD2_4_0 (vdsrc2_4_0 0) vsource dc=1.8
RVD2_4_0 (vdsrc2_4_0 vdd2_4_0) resistor r=50
VS0_2_4_0 (ss0_2_4_0 0) vsource dc=0
RS0_2_4_0 (ss0_2_4_0 s0_2_4_0) resistor r=50
VS1_2_4_0 (ss1_2_4_0 0) vsource dc=0
RS1_2_4_0 (ss1_2_4_0 s1_2_4_0) resistor r=50
VS2_2_4_0 (ss2_2_4_0 0) vsource dc=1.8
RS2_2_4_0 (ss2_2_4_0 s2_2_4_0) resistor r=50
VI0_2_4_0 (vs0_2_4_0 0) vsource dc=1.8 mag=1
RI0_2_4_0 (vs0_2_4_0 vi0_2_4_0) resistor r=50
VI1_2_4_0 (vs1_2_4_0 0) vsource dc=1.8 mag=0
RI1_2_4_0 (vs1_2_4_0 vi1_2_4_0) resistor r=50
VI2_2_4_0 (vs2_2_4_0 0) vsource dc=1.8 mag=0
RI2_2_4_0 (vs2_2_4_0 vi2_2_4_0) resistor r=50
VI3_2_4_0 (vs3_2_4_0 0) vsource dc=1.8 mag=0
RI3_2_4_0 (vs3_2_4_0 vi3_2_4_0) resistor r=50
VI4_2_4_0 (vs4_2_4_0 0) vsource dc=1.8 mag=0
RI4_2_4_0 (vs4_2_4_0 vi4_2_4_0) resistor r=50
VI5_2_4_0 (vs5_2_4_0 0) vsource dc=1.8 mag=0
RI5_2_4_0 (vs5_2_4_0 vi5_2_4_0) resistor r=50
VI6_2_4_0 (vs6_2_4_0 0) vsource dc=1.8 mag=0
RI6_2_4_0 (vs6_2_4_0 vi6_2_4_0) resistor r=50
VI7_2_4_0 (vs7_2_4_0 0) vsource dc=1.8 mag=0
RI7_2_4_0 (vs7_2_4_0 vi7_2_4_0) resistor r=50
X2_4_0 (vdd2_4_0 0 s2_2_4_0 s1_2_4_0 s0_2_4_0 vi7_2_4_0 vi6_2_4_0 vi5_2_4_0 vi4_2_4_0 vi3_2_4_0 vi2_2_4_0 vi1_2_4_0 vi0_2_4_0 vo2_4_0) input_mux_8to1
CL2_4_0 (vo2_4_0 0) capacitor c=1p
save vo2_4_0 VDD2_4_0:p
VDD2_4_1 (vdsrc2_4_1 0) vsource dc=1.8
RVD2_4_1 (vdsrc2_4_1 vdd2_4_1) resistor r=50
VS0_2_4_1 (ss0_2_4_1 0) vsource dc=0
RS0_2_4_1 (ss0_2_4_1 s0_2_4_1) resistor r=50
VS1_2_4_1 (ss1_2_4_1 0) vsource dc=0
RS1_2_4_1 (ss1_2_4_1 s1_2_4_1) resistor r=50
VS2_2_4_1 (ss2_2_4_1 0) vsource dc=1.8
RS2_2_4_1 (ss2_2_4_1 s2_2_4_1) resistor r=50
VI0_2_4_1 (vs0_2_4_1 0) vsource dc=1.8 mag=0
RI0_2_4_1 (vs0_2_4_1 vi0_2_4_1) resistor r=50
VI1_2_4_1 (vs1_2_4_1 0) vsource dc=1.8 mag=1
RI1_2_4_1 (vs1_2_4_1 vi1_2_4_1) resistor r=50
VI2_2_4_1 (vs2_2_4_1 0) vsource dc=1.8 mag=0
RI2_2_4_1 (vs2_2_4_1 vi2_2_4_1) resistor r=50
VI3_2_4_1 (vs3_2_4_1 0) vsource dc=1.8 mag=0
RI3_2_4_1 (vs3_2_4_1 vi3_2_4_1) resistor r=50
VI4_2_4_1 (vs4_2_4_1 0) vsource dc=1.8 mag=0
RI4_2_4_1 (vs4_2_4_1 vi4_2_4_1) resistor r=50
VI5_2_4_1 (vs5_2_4_1 0) vsource dc=1.8 mag=0
RI5_2_4_1 (vs5_2_4_1 vi5_2_4_1) resistor r=50
VI6_2_4_1 (vs6_2_4_1 0) vsource dc=1.8 mag=0
RI6_2_4_1 (vs6_2_4_1 vi6_2_4_1) resistor r=50
VI7_2_4_1 (vs7_2_4_1 0) vsource dc=1.8 mag=0
RI7_2_4_1 (vs7_2_4_1 vi7_2_4_1) resistor r=50
X2_4_1 (vdd2_4_1 0 s2_2_4_1 s1_2_4_1 s0_2_4_1 vi7_2_4_1 vi6_2_4_1 vi5_2_4_1 vi4_2_4_1 vi3_2_4_1 vi2_2_4_1 vi1_2_4_1 vi0_2_4_1 vo2_4_1) input_mux_8to1
CL2_4_1 (vo2_4_1 0) capacitor c=1p
save vo2_4_1 VDD2_4_1:p
VDD2_4_2 (vdsrc2_4_2 0) vsource dc=1.8
RVD2_4_2 (vdsrc2_4_2 vdd2_4_2) resistor r=50
VS0_2_4_2 (ss0_2_4_2 0) vsource dc=0
RS0_2_4_2 (ss0_2_4_2 s0_2_4_2) resistor r=50
VS1_2_4_2 (ss1_2_4_2 0) vsource dc=0
RS1_2_4_2 (ss1_2_4_2 s1_2_4_2) resistor r=50
VS2_2_4_2 (ss2_2_4_2 0) vsource dc=1.8
RS2_2_4_2 (ss2_2_4_2 s2_2_4_2) resistor r=50
VI0_2_4_2 (vs0_2_4_2 0) vsource dc=1.8 mag=0
RI0_2_4_2 (vs0_2_4_2 vi0_2_4_2) resistor r=50
VI1_2_4_2 (vs1_2_4_2 0) vsource dc=1.8 mag=0
RI1_2_4_2 (vs1_2_4_2 vi1_2_4_2) resistor r=50
VI2_2_4_2 (vs2_2_4_2 0) vsource dc=1.8 mag=1
RI2_2_4_2 (vs2_2_4_2 vi2_2_4_2) resistor r=50
VI3_2_4_2 (vs3_2_4_2 0) vsource dc=1.8 mag=0
RI3_2_4_2 (vs3_2_4_2 vi3_2_4_2) resistor r=50
VI4_2_4_2 (vs4_2_4_2 0) vsource dc=1.8 mag=0
RI4_2_4_2 (vs4_2_4_2 vi4_2_4_2) resistor r=50
VI5_2_4_2 (vs5_2_4_2 0) vsource dc=1.8 mag=0
RI5_2_4_2 (vs5_2_4_2 vi5_2_4_2) resistor r=50
VI6_2_4_2 (vs6_2_4_2 0) vsource dc=1.8 mag=0
RI6_2_4_2 (vs6_2_4_2 vi6_2_4_2) resistor r=50
VI7_2_4_2 (vs7_2_4_2 0) vsource dc=1.8 mag=0
RI7_2_4_2 (vs7_2_4_2 vi7_2_4_2) resistor r=50
X2_4_2 (vdd2_4_2 0 s2_2_4_2 s1_2_4_2 s0_2_4_2 vi7_2_4_2 vi6_2_4_2 vi5_2_4_2 vi4_2_4_2 vi3_2_4_2 vi2_2_4_2 vi1_2_4_2 vi0_2_4_2 vo2_4_2) input_mux_8to1
CL2_4_2 (vo2_4_2 0) capacitor c=1p
save vo2_4_2 VDD2_4_2:p
VDD2_4_3 (vdsrc2_4_3 0) vsource dc=1.8
RVD2_4_3 (vdsrc2_4_3 vdd2_4_3) resistor r=50
VS0_2_4_3 (ss0_2_4_3 0) vsource dc=0
RS0_2_4_3 (ss0_2_4_3 s0_2_4_3) resistor r=50
VS1_2_4_3 (ss1_2_4_3 0) vsource dc=0
RS1_2_4_3 (ss1_2_4_3 s1_2_4_3) resistor r=50
VS2_2_4_3 (ss2_2_4_3 0) vsource dc=1.8
RS2_2_4_3 (ss2_2_4_3 s2_2_4_3) resistor r=50
VI0_2_4_3 (vs0_2_4_3 0) vsource dc=1.8 mag=0
RI0_2_4_3 (vs0_2_4_3 vi0_2_4_3) resistor r=50
VI1_2_4_3 (vs1_2_4_3 0) vsource dc=1.8 mag=0
RI1_2_4_3 (vs1_2_4_3 vi1_2_4_3) resistor r=50
VI2_2_4_3 (vs2_2_4_3 0) vsource dc=1.8 mag=0
RI2_2_4_3 (vs2_2_4_3 vi2_2_4_3) resistor r=50
VI3_2_4_3 (vs3_2_4_3 0) vsource dc=1.8 mag=1
RI3_2_4_3 (vs3_2_4_3 vi3_2_4_3) resistor r=50
VI4_2_4_3 (vs4_2_4_3 0) vsource dc=1.8 mag=0
RI4_2_4_3 (vs4_2_4_3 vi4_2_4_3) resistor r=50
VI5_2_4_3 (vs5_2_4_3 0) vsource dc=1.8 mag=0
RI5_2_4_3 (vs5_2_4_3 vi5_2_4_3) resistor r=50
VI6_2_4_3 (vs6_2_4_3 0) vsource dc=1.8 mag=0
RI6_2_4_3 (vs6_2_4_3 vi6_2_4_3) resistor r=50
VI7_2_4_3 (vs7_2_4_3 0) vsource dc=1.8 mag=0
RI7_2_4_3 (vs7_2_4_3 vi7_2_4_3) resistor r=50
X2_4_3 (vdd2_4_3 0 s2_2_4_3 s1_2_4_3 s0_2_4_3 vi7_2_4_3 vi6_2_4_3 vi5_2_4_3 vi4_2_4_3 vi3_2_4_3 vi2_2_4_3 vi1_2_4_3 vi0_2_4_3 vo2_4_3) input_mux_8to1
CL2_4_3 (vo2_4_3 0) capacitor c=1p
save vo2_4_3 VDD2_4_3:p
VDD2_4_4 (vdsrc2_4_4 0) vsource dc=1.8
RVD2_4_4 (vdsrc2_4_4 vdd2_4_4) resistor r=50
VS0_2_4_4 (ss0_2_4_4 0) vsource dc=0
RS0_2_4_4 (ss0_2_4_4 s0_2_4_4) resistor r=50
VS1_2_4_4 (ss1_2_4_4 0) vsource dc=0
RS1_2_4_4 (ss1_2_4_4 s1_2_4_4) resistor r=50
VS2_2_4_4 (ss2_2_4_4 0) vsource dc=1.8
RS2_2_4_4 (ss2_2_4_4 s2_2_4_4) resistor r=50
VI0_2_4_4 (vs0_2_4_4 0) vsource dc=1.8 mag=0
RI0_2_4_4 (vs0_2_4_4 vi0_2_4_4) resistor r=50
VI1_2_4_4 (vs1_2_4_4 0) vsource dc=1.8 mag=0
RI1_2_4_4 (vs1_2_4_4 vi1_2_4_4) resistor r=50
VI2_2_4_4 (vs2_2_4_4 0) vsource dc=1.8 mag=0
RI2_2_4_4 (vs2_2_4_4 vi2_2_4_4) resistor r=50
VI3_2_4_4 (vs3_2_4_4 0) vsource dc=1.8 mag=0
RI3_2_4_4 (vs3_2_4_4 vi3_2_4_4) resistor r=50
VI4_2_4_4 (vs4_2_4_4 0) vsource dc=1.8 mag=1
RI4_2_4_4 (vs4_2_4_4 vi4_2_4_4) resistor r=50
VI5_2_4_4 (vs5_2_4_4 0) vsource dc=1.8 mag=0
RI5_2_4_4 (vs5_2_4_4 vi5_2_4_4) resistor r=50
VI6_2_4_4 (vs6_2_4_4 0) vsource dc=1.8 mag=0
RI6_2_4_4 (vs6_2_4_4 vi6_2_4_4) resistor r=50
VI7_2_4_4 (vs7_2_4_4 0) vsource dc=1.8 mag=0
RI7_2_4_4 (vs7_2_4_4 vi7_2_4_4) resistor r=50
X2_4_4 (vdd2_4_4 0 s2_2_4_4 s1_2_4_4 s0_2_4_4 vi7_2_4_4 vi6_2_4_4 vi5_2_4_4 vi4_2_4_4 vi3_2_4_4 vi2_2_4_4 vi1_2_4_4 vi0_2_4_4 vo2_4_4) input_mux_8to1
CL2_4_4 (vo2_4_4 0) capacitor c=1p
save vo2_4_4 VDD2_4_4:p
VDD2_4_5 (vdsrc2_4_5 0) vsource dc=1.8
RVD2_4_5 (vdsrc2_4_5 vdd2_4_5) resistor r=50
VS0_2_4_5 (ss0_2_4_5 0) vsource dc=0
RS0_2_4_5 (ss0_2_4_5 s0_2_4_5) resistor r=50
VS1_2_4_5 (ss1_2_4_5 0) vsource dc=0
RS1_2_4_5 (ss1_2_4_5 s1_2_4_5) resistor r=50
VS2_2_4_5 (ss2_2_4_5 0) vsource dc=1.8
RS2_2_4_5 (ss2_2_4_5 s2_2_4_5) resistor r=50
VI0_2_4_5 (vs0_2_4_5 0) vsource dc=1.8 mag=0
RI0_2_4_5 (vs0_2_4_5 vi0_2_4_5) resistor r=50
VI1_2_4_5 (vs1_2_4_5 0) vsource dc=1.8 mag=0
RI1_2_4_5 (vs1_2_4_5 vi1_2_4_5) resistor r=50
VI2_2_4_5 (vs2_2_4_5 0) vsource dc=1.8 mag=0
RI2_2_4_5 (vs2_2_4_5 vi2_2_4_5) resistor r=50
VI3_2_4_5 (vs3_2_4_5 0) vsource dc=1.8 mag=0
RI3_2_4_5 (vs3_2_4_5 vi3_2_4_5) resistor r=50
VI4_2_4_5 (vs4_2_4_5 0) vsource dc=1.8 mag=0
RI4_2_4_5 (vs4_2_4_5 vi4_2_4_5) resistor r=50
VI5_2_4_5 (vs5_2_4_5 0) vsource dc=1.8 mag=1
RI5_2_4_5 (vs5_2_4_5 vi5_2_4_5) resistor r=50
VI6_2_4_5 (vs6_2_4_5 0) vsource dc=1.8 mag=0
RI6_2_4_5 (vs6_2_4_5 vi6_2_4_5) resistor r=50
VI7_2_4_5 (vs7_2_4_5 0) vsource dc=1.8 mag=0
RI7_2_4_5 (vs7_2_4_5 vi7_2_4_5) resistor r=50
X2_4_5 (vdd2_4_5 0 s2_2_4_5 s1_2_4_5 s0_2_4_5 vi7_2_4_5 vi6_2_4_5 vi5_2_4_5 vi4_2_4_5 vi3_2_4_5 vi2_2_4_5 vi1_2_4_5 vi0_2_4_5 vo2_4_5) input_mux_8to1
CL2_4_5 (vo2_4_5 0) capacitor c=1p
save vo2_4_5 VDD2_4_5:p
VDD2_4_6 (vdsrc2_4_6 0) vsource dc=1.8
RVD2_4_6 (vdsrc2_4_6 vdd2_4_6) resistor r=50
VS0_2_4_6 (ss0_2_4_6 0) vsource dc=0
RS0_2_4_6 (ss0_2_4_6 s0_2_4_6) resistor r=50
VS1_2_4_6 (ss1_2_4_6 0) vsource dc=0
RS1_2_4_6 (ss1_2_4_6 s1_2_4_6) resistor r=50
VS2_2_4_6 (ss2_2_4_6 0) vsource dc=1.8
RS2_2_4_6 (ss2_2_4_6 s2_2_4_6) resistor r=50
VI0_2_4_6 (vs0_2_4_6 0) vsource dc=1.8 mag=0
RI0_2_4_6 (vs0_2_4_6 vi0_2_4_6) resistor r=50
VI1_2_4_6 (vs1_2_4_6 0) vsource dc=1.8 mag=0
RI1_2_4_6 (vs1_2_4_6 vi1_2_4_6) resistor r=50
VI2_2_4_6 (vs2_2_4_6 0) vsource dc=1.8 mag=0
RI2_2_4_6 (vs2_2_4_6 vi2_2_4_6) resistor r=50
VI3_2_4_6 (vs3_2_4_6 0) vsource dc=1.8 mag=0
RI3_2_4_6 (vs3_2_4_6 vi3_2_4_6) resistor r=50
VI4_2_4_6 (vs4_2_4_6 0) vsource dc=1.8 mag=0
RI4_2_4_6 (vs4_2_4_6 vi4_2_4_6) resistor r=50
VI5_2_4_6 (vs5_2_4_6 0) vsource dc=1.8 mag=0
RI5_2_4_6 (vs5_2_4_6 vi5_2_4_6) resistor r=50
VI6_2_4_6 (vs6_2_4_6 0) vsource dc=1.8 mag=1
RI6_2_4_6 (vs6_2_4_6 vi6_2_4_6) resistor r=50
VI7_2_4_6 (vs7_2_4_6 0) vsource dc=1.8 mag=0
RI7_2_4_6 (vs7_2_4_6 vi7_2_4_6) resistor r=50
X2_4_6 (vdd2_4_6 0 s2_2_4_6 s1_2_4_6 s0_2_4_6 vi7_2_4_6 vi6_2_4_6 vi5_2_4_6 vi4_2_4_6 vi3_2_4_6 vi2_2_4_6 vi1_2_4_6 vi0_2_4_6 vo2_4_6) input_mux_8to1
CL2_4_6 (vo2_4_6 0) capacitor c=1p
save vo2_4_6 VDD2_4_6:p
VDD2_4_7 (vdsrc2_4_7 0) vsource dc=1.8
RVD2_4_7 (vdsrc2_4_7 vdd2_4_7) resistor r=50
VS0_2_4_7 (ss0_2_4_7 0) vsource dc=0
RS0_2_4_7 (ss0_2_4_7 s0_2_4_7) resistor r=50
VS1_2_4_7 (ss1_2_4_7 0) vsource dc=0
RS1_2_4_7 (ss1_2_4_7 s1_2_4_7) resistor r=50
VS2_2_4_7 (ss2_2_4_7 0) vsource dc=1.8
RS2_2_4_7 (ss2_2_4_7 s2_2_4_7) resistor r=50
VI0_2_4_7 (vs0_2_4_7 0) vsource dc=1.8 mag=0
RI0_2_4_7 (vs0_2_4_7 vi0_2_4_7) resistor r=50
VI1_2_4_7 (vs1_2_4_7 0) vsource dc=1.8 mag=0
RI1_2_4_7 (vs1_2_4_7 vi1_2_4_7) resistor r=50
VI2_2_4_7 (vs2_2_4_7 0) vsource dc=1.8 mag=0
RI2_2_4_7 (vs2_2_4_7 vi2_2_4_7) resistor r=50
VI3_2_4_7 (vs3_2_4_7 0) vsource dc=1.8 mag=0
RI3_2_4_7 (vs3_2_4_7 vi3_2_4_7) resistor r=50
VI4_2_4_7 (vs4_2_4_7 0) vsource dc=1.8 mag=0
RI4_2_4_7 (vs4_2_4_7 vi4_2_4_7) resistor r=50
VI5_2_4_7 (vs5_2_4_7 0) vsource dc=1.8 mag=0
RI5_2_4_7 (vs5_2_4_7 vi5_2_4_7) resistor r=50
VI6_2_4_7 (vs6_2_4_7 0) vsource dc=1.8 mag=0
RI6_2_4_7 (vs6_2_4_7 vi6_2_4_7) resistor r=50
VI7_2_4_7 (vs7_2_4_7 0) vsource dc=1.8 mag=1
RI7_2_4_7 (vs7_2_4_7 vi7_2_4_7) resistor r=50
X2_4_7 (vdd2_4_7 0 s2_2_4_7 s1_2_4_7 s0_2_4_7 vi7_2_4_7 vi6_2_4_7 vi5_2_4_7 vi4_2_4_7 vi3_2_4_7 vi2_2_4_7 vi1_2_4_7 vi0_2_4_7 vo2_4_7) input_mux_8to1
CL2_4_7 (vo2_4_7 0) capacitor c=1p
save vo2_4_7 VDD2_4_7:p
VDD2_5_0 (vdsrc2_5_0 0) vsource dc=1.8
RVD2_5_0 (vdsrc2_5_0 vdd2_5_0) resistor r=50
VS0_2_5_0 (ss0_2_5_0 0) vsource dc=1.8
RS0_2_5_0 (ss0_2_5_0 s0_2_5_0) resistor r=50
VS1_2_5_0 (ss1_2_5_0 0) vsource dc=0
RS1_2_5_0 (ss1_2_5_0 s1_2_5_0) resistor r=50
VS2_2_5_0 (ss2_2_5_0 0) vsource dc=1.8
RS2_2_5_0 (ss2_2_5_0 s2_2_5_0) resistor r=50
VI0_2_5_0 (vs0_2_5_0 0) vsource dc=1.8 mag=1
RI0_2_5_0 (vs0_2_5_0 vi0_2_5_0) resistor r=50
VI1_2_5_0 (vs1_2_5_0 0) vsource dc=1.8 mag=0
RI1_2_5_0 (vs1_2_5_0 vi1_2_5_0) resistor r=50
VI2_2_5_0 (vs2_2_5_0 0) vsource dc=1.8 mag=0
RI2_2_5_0 (vs2_2_5_0 vi2_2_5_0) resistor r=50
VI3_2_5_0 (vs3_2_5_0 0) vsource dc=1.8 mag=0
RI3_2_5_0 (vs3_2_5_0 vi3_2_5_0) resistor r=50
VI4_2_5_0 (vs4_2_5_0 0) vsource dc=1.8 mag=0
RI4_2_5_0 (vs4_2_5_0 vi4_2_5_0) resistor r=50
VI5_2_5_0 (vs5_2_5_0 0) vsource dc=1.8 mag=0
RI5_2_5_0 (vs5_2_5_0 vi5_2_5_0) resistor r=50
VI6_2_5_0 (vs6_2_5_0 0) vsource dc=1.8 mag=0
RI6_2_5_0 (vs6_2_5_0 vi6_2_5_0) resistor r=50
VI7_2_5_0 (vs7_2_5_0 0) vsource dc=1.8 mag=0
RI7_2_5_0 (vs7_2_5_0 vi7_2_5_0) resistor r=50
X2_5_0 (vdd2_5_0 0 s2_2_5_0 s1_2_5_0 s0_2_5_0 vi7_2_5_0 vi6_2_5_0 vi5_2_5_0 vi4_2_5_0 vi3_2_5_0 vi2_2_5_0 vi1_2_5_0 vi0_2_5_0 vo2_5_0) input_mux_8to1
CL2_5_0 (vo2_5_0 0) capacitor c=1p
save vo2_5_0 VDD2_5_0:p
VDD2_5_1 (vdsrc2_5_1 0) vsource dc=1.8
RVD2_5_1 (vdsrc2_5_1 vdd2_5_1) resistor r=50
VS0_2_5_1 (ss0_2_5_1 0) vsource dc=1.8
RS0_2_5_1 (ss0_2_5_1 s0_2_5_1) resistor r=50
VS1_2_5_1 (ss1_2_5_1 0) vsource dc=0
RS1_2_5_1 (ss1_2_5_1 s1_2_5_1) resistor r=50
VS2_2_5_1 (ss2_2_5_1 0) vsource dc=1.8
RS2_2_5_1 (ss2_2_5_1 s2_2_5_1) resistor r=50
VI0_2_5_1 (vs0_2_5_1 0) vsource dc=1.8 mag=0
RI0_2_5_1 (vs0_2_5_1 vi0_2_5_1) resistor r=50
VI1_2_5_1 (vs1_2_5_1 0) vsource dc=1.8 mag=1
RI1_2_5_1 (vs1_2_5_1 vi1_2_5_1) resistor r=50
VI2_2_5_1 (vs2_2_5_1 0) vsource dc=1.8 mag=0
RI2_2_5_1 (vs2_2_5_1 vi2_2_5_1) resistor r=50
VI3_2_5_1 (vs3_2_5_1 0) vsource dc=1.8 mag=0
RI3_2_5_1 (vs3_2_5_1 vi3_2_5_1) resistor r=50
VI4_2_5_1 (vs4_2_5_1 0) vsource dc=1.8 mag=0
RI4_2_5_1 (vs4_2_5_1 vi4_2_5_1) resistor r=50
VI5_2_5_1 (vs5_2_5_1 0) vsource dc=1.8 mag=0
RI5_2_5_1 (vs5_2_5_1 vi5_2_5_1) resistor r=50
VI6_2_5_1 (vs6_2_5_1 0) vsource dc=1.8 mag=0
RI6_2_5_1 (vs6_2_5_1 vi6_2_5_1) resistor r=50
VI7_2_5_1 (vs7_2_5_1 0) vsource dc=1.8 mag=0
RI7_2_5_1 (vs7_2_5_1 vi7_2_5_1) resistor r=50
X2_5_1 (vdd2_5_1 0 s2_2_5_1 s1_2_5_1 s0_2_5_1 vi7_2_5_1 vi6_2_5_1 vi5_2_5_1 vi4_2_5_1 vi3_2_5_1 vi2_2_5_1 vi1_2_5_1 vi0_2_5_1 vo2_5_1) input_mux_8to1
CL2_5_1 (vo2_5_1 0) capacitor c=1p
save vo2_5_1 VDD2_5_1:p
VDD2_5_2 (vdsrc2_5_2 0) vsource dc=1.8
RVD2_5_2 (vdsrc2_5_2 vdd2_5_2) resistor r=50
VS0_2_5_2 (ss0_2_5_2 0) vsource dc=1.8
RS0_2_5_2 (ss0_2_5_2 s0_2_5_2) resistor r=50
VS1_2_5_2 (ss1_2_5_2 0) vsource dc=0
RS1_2_5_2 (ss1_2_5_2 s1_2_5_2) resistor r=50
VS2_2_5_2 (ss2_2_5_2 0) vsource dc=1.8
RS2_2_5_2 (ss2_2_5_2 s2_2_5_2) resistor r=50
VI0_2_5_2 (vs0_2_5_2 0) vsource dc=1.8 mag=0
RI0_2_5_2 (vs0_2_5_2 vi0_2_5_2) resistor r=50
VI1_2_5_2 (vs1_2_5_2 0) vsource dc=1.8 mag=0
RI1_2_5_2 (vs1_2_5_2 vi1_2_5_2) resistor r=50
VI2_2_5_2 (vs2_2_5_2 0) vsource dc=1.8 mag=1
RI2_2_5_2 (vs2_2_5_2 vi2_2_5_2) resistor r=50
VI3_2_5_2 (vs3_2_5_2 0) vsource dc=1.8 mag=0
RI3_2_5_2 (vs3_2_5_2 vi3_2_5_2) resistor r=50
VI4_2_5_2 (vs4_2_5_2 0) vsource dc=1.8 mag=0
RI4_2_5_2 (vs4_2_5_2 vi4_2_5_2) resistor r=50
VI5_2_5_2 (vs5_2_5_2 0) vsource dc=1.8 mag=0
RI5_2_5_2 (vs5_2_5_2 vi5_2_5_2) resistor r=50
VI6_2_5_2 (vs6_2_5_2 0) vsource dc=1.8 mag=0
RI6_2_5_2 (vs6_2_5_2 vi6_2_5_2) resistor r=50
VI7_2_5_2 (vs7_2_5_2 0) vsource dc=1.8 mag=0
RI7_2_5_2 (vs7_2_5_2 vi7_2_5_2) resistor r=50
X2_5_2 (vdd2_5_2 0 s2_2_5_2 s1_2_5_2 s0_2_5_2 vi7_2_5_2 vi6_2_5_2 vi5_2_5_2 vi4_2_5_2 vi3_2_5_2 vi2_2_5_2 vi1_2_5_2 vi0_2_5_2 vo2_5_2) input_mux_8to1
CL2_5_2 (vo2_5_2 0) capacitor c=1p
save vo2_5_2 VDD2_5_2:p
VDD2_5_3 (vdsrc2_5_3 0) vsource dc=1.8
RVD2_5_3 (vdsrc2_5_3 vdd2_5_3) resistor r=50
VS0_2_5_3 (ss0_2_5_3 0) vsource dc=1.8
RS0_2_5_3 (ss0_2_5_3 s0_2_5_3) resistor r=50
VS1_2_5_3 (ss1_2_5_3 0) vsource dc=0
RS1_2_5_3 (ss1_2_5_3 s1_2_5_3) resistor r=50
VS2_2_5_3 (ss2_2_5_3 0) vsource dc=1.8
RS2_2_5_3 (ss2_2_5_3 s2_2_5_3) resistor r=50
VI0_2_5_3 (vs0_2_5_3 0) vsource dc=1.8 mag=0
RI0_2_5_3 (vs0_2_5_3 vi0_2_5_3) resistor r=50
VI1_2_5_3 (vs1_2_5_3 0) vsource dc=1.8 mag=0
RI1_2_5_3 (vs1_2_5_3 vi1_2_5_3) resistor r=50
VI2_2_5_3 (vs2_2_5_3 0) vsource dc=1.8 mag=0
RI2_2_5_3 (vs2_2_5_3 vi2_2_5_3) resistor r=50
VI3_2_5_3 (vs3_2_5_3 0) vsource dc=1.8 mag=1
RI3_2_5_3 (vs3_2_5_3 vi3_2_5_3) resistor r=50
VI4_2_5_3 (vs4_2_5_3 0) vsource dc=1.8 mag=0
RI4_2_5_3 (vs4_2_5_3 vi4_2_5_3) resistor r=50
VI5_2_5_3 (vs5_2_5_3 0) vsource dc=1.8 mag=0
RI5_2_5_3 (vs5_2_5_3 vi5_2_5_3) resistor r=50
VI6_2_5_3 (vs6_2_5_3 0) vsource dc=1.8 mag=0
RI6_2_5_3 (vs6_2_5_3 vi6_2_5_3) resistor r=50
VI7_2_5_3 (vs7_2_5_3 0) vsource dc=1.8 mag=0
RI7_2_5_3 (vs7_2_5_3 vi7_2_5_3) resistor r=50
X2_5_3 (vdd2_5_3 0 s2_2_5_3 s1_2_5_3 s0_2_5_3 vi7_2_5_3 vi6_2_5_3 vi5_2_5_3 vi4_2_5_3 vi3_2_5_3 vi2_2_5_3 vi1_2_5_3 vi0_2_5_3 vo2_5_3) input_mux_8to1
CL2_5_3 (vo2_5_3 0) capacitor c=1p
save vo2_5_3 VDD2_5_3:p
VDD2_5_4 (vdsrc2_5_4 0) vsource dc=1.8
RVD2_5_4 (vdsrc2_5_4 vdd2_5_4) resistor r=50
VS0_2_5_4 (ss0_2_5_4 0) vsource dc=1.8
RS0_2_5_4 (ss0_2_5_4 s0_2_5_4) resistor r=50
VS1_2_5_4 (ss1_2_5_4 0) vsource dc=0
RS1_2_5_4 (ss1_2_5_4 s1_2_5_4) resistor r=50
VS2_2_5_4 (ss2_2_5_4 0) vsource dc=1.8
RS2_2_5_4 (ss2_2_5_4 s2_2_5_4) resistor r=50
VI0_2_5_4 (vs0_2_5_4 0) vsource dc=1.8 mag=0
RI0_2_5_4 (vs0_2_5_4 vi0_2_5_4) resistor r=50
VI1_2_5_4 (vs1_2_5_4 0) vsource dc=1.8 mag=0
RI1_2_5_4 (vs1_2_5_4 vi1_2_5_4) resistor r=50
VI2_2_5_4 (vs2_2_5_4 0) vsource dc=1.8 mag=0
RI2_2_5_4 (vs2_2_5_4 vi2_2_5_4) resistor r=50
VI3_2_5_4 (vs3_2_5_4 0) vsource dc=1.8 mag=0
RI3_2_5_4 (vs3_2_5_4 vi3_2_5_4) resistor r=50
VI4_2_5_4 (vs4_2_5_4 0) vsource dc=1.8 mag=1
RI4_2_5_4 (vs4_2_5_4 vi4_2_5_4) resistor r=50
VI5_2_5_4 (vs5_2_5_4 0) vsource dc=1.8 mag=0
RI5_2_5_4 (vs5_2_5_4 vi5_2_5_4) resistor r=50
VI6_2_5_4 (vs6_2_5_4 0) vsource dc=1.8 mag=0
RI6_2_5_4 (vs6_2_5_4 vi6_2_5_4) resistor r=50
VI7_2_5_4 (vs7_2_5_4 0) vsource dc=1.8 mag=0
RI7_2_5_4 (vs7_2_5_4 vi7_2_5_4) resistor r=50
X2_5_4 (vdd2_5_4 0 s2_2_5_4 s1_2_5_4 s0_2_5_4 vi7_2_5_4 vi6_2_5_4 vi5_2_5_4 vi4_2_5_4 vi3_2_5_4 vi2_2_5_4 vi1_2_5_4 vi0_2_5_4 vo2_5_4) input_mux_8to1
CL2_5_4 (vo2_5_4 0) capacitor c=1p
save vo2_5_4 VDD2_5_4:p
VDD2_5_5 (vdsrc2_5_5 0) vsource dc=1.8
RVD2_5_5 (vdsrc2_5_5 vdd2_5_5) resistor r=50
VS0_2_5_5 (ss0_2_5_5 0) vsource dc=1.8
RS0_2_5_5 (ss0_2_5_5 s0_2_5_5) resistor r=50
VS1_2_5_5 (ss1_2_5_5 0) vsource dc=0
RS1_2_5_5 (ss1_2_5_5 s1_2_5_5) resistor r=50
VS2_2_5_5 (ss2_2_5_5 0) vsource dc=1.8
RS2_2_5_5 (ss2_2_5_5 s2_2_5_5) resistor r=50
VI0_2_5_5 (vs0_2_5_5 0) vsource dc=1.8 mag=0
RI0_2_5_5 (vs0_2_5_5 vi0_2_5_5) resistor r=50
VI1_2_5_5 (vs1_2_5_5 0) vsource dc=1.8 mag=0
RI1_2_5_5 (vs1_2_5_5 vi1_2_5_5) resistor r=50
VI2_2_5_5 (vs2_2_5_5 0) vsource dc=1.8 mag=0
RI2_2_5_5 (vs2_2_5_5 vi2_2_5_5) resistor r=50
VI3_2_5_5 (vs3_2_5_5 0) vsource dc=1.8 mag=0
RI3_2_5_5 (vs3_2_5_5 vi3_2_5_5) resistor r=50
VI4_2_5_5 (vs4_2_5_5 0) vsource dc=1.8 mag=0
RI4_2_5_5 (vs4_2_5_5 vi4_2_5_5) resistor r=50
VI5_2_5_5 (vs5_2_5_5 0) vsource dc=1.8 mag=1
RI5_2_5_5 (vs5_2_5_5 vi5_2_5_5) resistor r=50
VI6_2_5_5 (vs6_2_5_5 0) vsource dc=1.8 mag=0
RI6_2_5_5 (vs6_2_5_5 vi6_2_5_5) resistor r=50
VI7_2_5_5 (vs7_2_5_5 0) vsource dc=1.8 mag=0
RI7_2_5_5 (vs7_2_5_5 vi7_2_5_5) resistor r=50
X2_5_5 (vdd2_5_5 0 s2_2_5_5 s1_2_5_5 s0_2_5_5 vi7_2_5_5 vi6_2_5_5 vi5_2_5_5 vi4_2_5_5 vi3_2_5_5 vi2_2_5_5 vi1_2_5_5 vi0_2_5_5 vo2_5_5) input_mux_8to1
CL2_5_5 (vo2_5_5 0) capacitor c=1p
save vo2_5_5 VDD2_5_5:p
VDD2_5_6 (vdsrc2_5_6 0) vsource dc=1.8
RVD2_5_6 (vdsrc2_5_6 vdd2_5_6) resistor r=50
VS0_2_5_6 (ss0_2_5_6 0) vsource dc=1.8
RS0_2_5_6 (ss0_2_5_6 s0_2_5_6) resistor r=50
VS1_2_5_6 (ss1_2_5_6 0) vsource dc=0
RS1_2_5_6 (ss1_2_5_6 s1_2_5_6) resistor r=50
VS2_2_5_6 (ss2_2_5_6 0) vsource dc=1.8
RS2_2_5_6 (ss2_2_5_6 s2_2_5_6) resistor r=50
VI0_2_5_6 (vs0_2_5_6 0) vsource dc=1.8 mag=0
RI0_2_5_6 (vs0_2_5_6 vi0_2_5_6) resistor r=50
VI1_2_5_6 (vs1_2_5_6 0) vsource dc=1.8 mag=0
RI1_2_5_6 (vs1_2_5_6 vi1_2_5_6) resistor r=50
VI2_2_5_6 (vs2_2_5_6 0) vsource dc=1.8 mag=0
RI2_2_5_6 (vs2_2_5_6 vi2_2_5_6) resistor r=50
VI3_2_5_6 (vs3_2_5_6 0) vsource dc=1.8 mag=0
RI3_2_5_6 (vs3_2_5_6 vi3_2_5_6) resistor r=50
VI4_2_5_6 (vs4_2_5_6 0) vsource dc=1.8 mag=0
RI4_2_5_6 (vs4_2_5_6 vi4_2_5_6) resistor r=50
VI5_2_5_6 (vs5_2_5_6 0) vsource dc=1.8 mag=0
RI5_2_5_6 (vs5_2_5_6 vi5_2_5_6) resistor r=50
VI6_2_5_6 (vs6_2_5_6 0) vsource dc=1.8 mag=1
RI6_2_5_6 (vs6_2_5_6 vi6_2_5_6) resistor r=50
VI7_2_5_6 (vs7_2_5_6 0) vsource dc=1.8 mag=0
RI7_2_5_6 (vs7_2_5_6 vi7_2_5_6) resistor r=50
X2_5_6 (vdd2_5_6 0 s2_2_5_6 s1_2_5_6 s0_2_5_6 vi7_2_5_6 vi6_2_5_6 vi5_2_5_6 vi4_2_5_6 vi3_2_5_6 vi2_2_5_6 vi1_2_5_6 vi0_2_5_6 vo2_5_6) input_mux_8to1
CL2_5_6 (vo2_5_6 0) capacitor c=1p
save vo2_5_6 VDD2_5_6:p
VDD2_5_7 (vdsrc2_5_7 0) vsource dc=1.8
RVD2_5_7 (vdsrc2_5_7 vdd2_5_7) resistor r=50
VS0_2_5_7 (ss0_2_5_7 0) vsource dc=1.8
RS0_2_5_7 (ss0_2_5_7 s0_2_5_7) resistor r=50
VS1_2_5_7 (ss1_2_5_7 0) vsource dc=0
RS1_2_5_7 (ss1_2_5_7 s1_2_5_7) resistor r=50
VS2_2_5_7 (ss2_2_5_7 0) vsource dc=1.8
RS2_2_5_7 (ss2_2_5_7 s2_2_5_7) resistor r=50
VI0_2_5_7 (vs0_2_5_7 0) vsource dc=1.8 mag=0
RI0_2_5_7 (vs0_2_5_7 vi0_2_5_7) resistor r=50
VI1_2_5_7 (vs1_2_5_7 0) vsource dc=1.8 mag=0
RI1_2_5_7 (vs1_2_5_7 vi1_2_5_7) resistor r=50
VI2_2_5_7 (vs2_2_5_7 0) vsource dc=1.8 mag=0
RI2_2_5_7 (vs2_2_5_7 vi2_2_5_7) resistor r=50
VI3_2_5_7 (vs3_2_5_7 0) vsource dc=1.8 mag=0
RI3_2_5_7 (vs3_2_5_7 vi3_2_5_7) resistor r=50
VI4_2_5_7 (vs4_2_5_7 0) vsource dc=1.8 mag=0
RI4_2_5_7 (vs4_2_5_7 vi4_2_5_7) resistor r=50
VI5_2_5_7 (vs5_2_5_7 0) vsource dc=1.8 mag=0
RI5_2_5_7 (vs5_2_5_7 vi5_2_5_7) resistor r=50
VI6_2_5_7 (vs6_2_5_7 0) vsource dc=1.8 mag=0
RI6_2_5_7 (vs6_2_5_7 vi6_2_5_7) resistor r=50
VI7_2_5_7 (vs7_2_5_7 0) vsource dc=1.8 mag=1
RI7_2_5_7 (vs7_2_5_7 vi7_2_5_7) resistor r=50
X2_5_7 (vdd2_5_7 0 s2_2_5_7 s1_2_5_7 s0_2_5_7 vi7_2_5_7 vi6_2_5_7 vi5_2_5_7 vi4_2_5_7 vi3_2_5_7 vi2_2_5_7 vi1_2_5_7 vi0_2_5_7 vo2_5_7) input_mux_8to1
CL2_5_7 (vo2_5_7 0) capacitor c=1p
save vo2_5_7 VDD2_5_7:p
VDD2_6_0 (vdsrc2_6_0 0) vsource dc=1.8
RVD2_6_0 (vdsrc2_6_0 vdd2_6_0) resistor r=50
VS0_2_6_0 (ss0_2_6_0 0) vsource dc=0
RS0_2_6_0 (ss0_2_6_0 s0_2_6_0) resistor r=50
VS1_2_6_0 (ss1_2_6_0 0) vsource dc=1.8
RS1_2_6_0 (ss1_2_6_0 s1_2_6_0) resistor r=50
VS2_2_6_0 (ss2_2_6_0 0) vsource dc=1.8
RS2_2_6_0 (ss2_2_6_0 s2_2_6_0) resistor r=50
VI0_2_6_0 (vs0_2_6_0 0) vsource dc=1.8 mag=1
RI0_2_6_0 (vs0_2_6_0 vi0_2_6_0) resistor r=50
VI1_2_6_0 (vs1_2_6_0 0) vsource dc=1.8 mag=0
RI1_2_6_0 (vs1_2_6_0 vi1_2_6_0) resistor r=50
VI2_2_6_0 (vs2_2_6_0 0) vsource dc=1.8 mag=0
RI2_2_6_0 (vs2_2_6_0 vi2_2_6_0) resistor r=50
VI3_2_6_0 (vs3_2_6_0 0) vsource dc=1.8 mag=0
RI3_2_6_0 (vs3_2_6_0 vi3_2_6_0) resistor r=50
VI4_2_6_0 (vs4_2_6_0 0) vsource dc=1.8 mag=0
RI4_2_6_0 (vs4_2_6_0 vi4_2_6_0) resistor r=50
VI5_2_6_0 (vs5_2_6_0 0) vsource dc=1.8 mag=0
RI5_2_6_0 (vs5_2_6_0 vi5_2_6_0) resistor r=50
VI6_2_6_0 (vs6_2_6_0 0) vsource dc=1.8 mag=0
RI6_2_6_0 (vs6_2_6_0 vi6_2_6_0) resistor r=50
VI7_2_6_0 (vs7_2_6_0 0) vsource dc=1.8 mag=0
RI7_2_6_0 (vs7_2_6_0 vi7_2_6_0) resistor r=50
X2_6_0 (vdd2_6_0 0 s2_2_6_0 s1_2_6_0 s0_2_6_0 vi7_2_6_0 vi6_2_6_0 vi5_2_6_0 vi4_2_6_0 vi3_2_6_0 vi2_2_6_0 vi1_2_6_0 vi0_2_6_0 vo2_6_0) input_mux_8to1
CL2_6_0 (vo2_6_0 0) capacitor c=1p
save vo2_6_0 VDD2_6_0:p
VDD2_6_1 (vdsrc2_6_1 0) vsource dc=1.8
RVD2_6_1 (vdsrc2_6_1 vdd2_6_1) resistor r=50
VS0_2_6_1 (ss0_2_6_1 0) vsource dc=0
RS0_2_6_1 (ss0_2_6_1 s0_2_6_1) resistor r=50
VS1_2_6_1 (ss1_2_6_1 0) vsource dc=1.8
RS1_2_6_1 (ss1_2_6_1 s1_2_6_1) resistor r=50
VS2_2_6_1 (ss2_2_6_1 0) vsource dc=1.8
RS2_2_6_1 (ss2_2_6_1 s2_2_6_1) resistor r=50
VI0_2_6_1 (vs0_2_6_1 0) vsource dc=1.8 mag=0
RI0_2_6_1 (vs0_2_6_1 vi0_2_6_1) resistor r=50
VI1_2_6_1 (vs1_2_6_1 0) vsource dc=1.8 mag=1
RI1_2_6_1 (vs1_2_6_1 vi1_2_6_1) resistor r=50
VI2_2_6_1 (vs2_2_6_1 0) vsource dc=1.8 mag=0
RI2_2_6_1 (vs2_2_6_1 vi2_2_6_1) resistor r=50
VI3_2_6_1 (vs3_2_6_1 0) vsource dc=1.8 mag=0
RI3_2_6_1 (vs3_2_6_1 vi3_2_6_1) resistor r=50
VI4_2_6_1 (vs4_2_6_1 0) vsource dc=1.8 mag=0
RI4_2_6_1 (vs4_2_6_1 vi4_2_6_1) resistor r=50
VI5_2_6_1 (vs5_2_6_1 0) vsource dc=1.8 mag=0
RI5_2_6_1 (vs5_2_6_1 vi5_2_6_1) resistor r=50
VI6_2_6_1 (vs6_2_6_1 0) vsource dc=1.8 mag=0
RI6_2_6_1 (vs6_2_6_1 vi6_2_6_1) resistor r=50
VI7_2_6_1 (vs7_2_6_1 0) vsource dc=1.8 mag=0
RI7_2_6_1 (vs7_2_6_1 vi7_2_6_1) resistor r=50
X2_6_1 (vdd2_6_1 0 s2_2_6_1 s1_2_6_1 s0_2_6_1 vi7_2_6_1 vi6_2_6_1 vi5_2_6_1 vi4_2_6_1 vi3_2_6_1 vi2_2_6_1 vi1_2_6_1 vi0_2_6_1 vo2_6_1) input_mux_8to1
CL2_6_1 (vo2_6_1 0) capacitor c=1p
save vo2_6_1 VDD2_6_1:p
VDD2_6_2 (vdsrc2_6_2 0) vsource dc=1.8
RVD2_6_2 (vdsrc2_6_2 vdd2_6_2) resistor r=50
VS0_2_6_2 (ss0_2_6_2 0) vsource dc=0
RS0_2_6_2 (ss0_2_6_2 s0_2_6_2) resistor r=50
VS1_2_6_2 (ss1_2_6_2 0) vsource dc=1.8
RS1_2_6_2 (ss1_2_6_2 s1_2_6_2) resistor r=50
VS2_2_6_2 (ss2_2_6_2 0) vsource dc=1.8
RS2_2_6_2 (ss2_2_6_2 s2_2_6_2) resistor r=50
VI0_2_6_2 (vs0_2_6_2 0) vsource dc=1.8 mag=0
RI0_2_6_2 (vs0_2_6_2 vi0_2_6_2) resistor r=50
VI1_2_6_2 (vs1_2_6_2 0) vsource dc=1.8 mag=0
RI1_2_6_2 (vs1_2_6_2 vi1_2_6_2) resistor r=50
VI2_2_6_2 (vs2_2_6_2 0) vsource dc=1.8 mag=1
RI2_2_6_2 (vs2_2_6_2 vi2_2_6_2) resistor r=50
VI3_2_6_2 (vs3_2_6_2 0) vsource dc=1.8 mag=0
RI3_2_6_2 (vs3_2_6_2 vi3_2_6_2) resistor r=50
VI4_2_6_2 (vs4_2_6_2 0) vsource dc=1.8 mag=0
RI4_2_6_2 (vs4_2_6_2 vi4_2_6_2) resistor r=50
VI5_2_6_2 (vs5_2_6_2 0) vsource dc=1.8 mag=0
RI5_2_6_2 (vs5_2_6_2 vi5_2_6_2) resistor r=50
VI6_2_6_2 (vs6_2_6_2 0) vsource dc=1.8 mag=0
RI6_2_6_2 (vs6_2_6_2 vi6_2_6_2) resistor r=50
VI7_2_6_2 (vs7_2_6_2 0) vsource dc=1.8 mag=0
RI7_2_6_2 (vs7_2_6_2 vi7_2_6_2) resistor r=50
X2_6_2 (vdd2_6_2 0 s2_2_6_2 s1_2_6_2 s0_2_6_2 vi7_2_6_2 vi6_2_6_2 vi5_2_6_2 vi4_2_6_2 vi3_2_6_2 vi2_2_6_2 vi1_2_6_2 vi0_2_6_2 vo2_6_2) input_mux_8to1
CL2_6_2 (vo2_6_2 0) capacitor c=1p
save vo2_6_2 VDD2_6_2:p
VDD2_6_3 (vdsrc2_6_3 0) vsource dc=1.8
RVD2_6_3 (vdsrc2_6_3 vdd2_6_3) resistor r=50
VS0_2_6_3 (ss0_2_6_3 0) vsource dc=0
RS0_2_6_3 (ss0_2_6_3 s0_2_6_3) resistor r=50
VS1_2_6_3 (ss1_2_6_3 0) vsource dc=1.8
RS1_2_6_3 (ss1_2_6_3 s1_2_6_3) resistor r=50
VS2_2_6_3 (ss2_2_6_3 0) vsource dc=1.8
RS2_2_6_3 (ss2_2_6_3 s2_2_6_3) resistor r=50
VI0_2_6_3 (vs0_2_6_3 0) vsource dc=1.8 mag=0
RI0_2_6_3 (vs0_2_6_3 vi0_2_6_3) resistor r=50
VI1_2_6_3 (vs1_2_6_3 0) vsource dc=1.8 mag=0
RI1_2_6_3 (vs1_2_6_3 vi1_2_6_3) resistor r=50
VI2_2_6_3 (vs2_2_6_3 0) vsource dc=1.8 mag=0
RI2_2_6_3 (vs2_2_6_3 vi2_2_6_3) resistor r=50
VI3_2_6_3 (vs3_2_6_3 0) vsource dc=1.8 mag=1
RI3_2_6_3 (vs3_2_6_3 vi3_2_6_3) resistor r=50
VI4_2_6_3 (vs4_2_6_3 0) vsource dc=1.8 mag=0
RI4_2_6_3 (vs4_2_6_3 vi4_2_6_3) resistor r=50
VI5_2_6_3 (vs5_2_6_3 0) vsource dc=1.8 mag=0
RI5_2_6_3 (vs5_2_6_3 vi5_2_6_3) resistor r=50
VI6_2_6_3 (vs6_2_6_3 0) vsource dc=1.8 mag=0
RI6_2_6_3 (vs6_2_6_3 vi6_2_6_3) resistor r=50
VI7_2_6_3 (vs7_2_6_3 0) vsource dc=1.8 mag=0
RI7_2_6_3 (vs7_2_6_3 vi7_2_6_3) resistor r=50
X2_6_3 (vdd2_6_3 0 s2_2_6_3 s1_2_6_3 s0_2_6_3 vi7_2_6_3 vi6_2_6_3 vi5_2_6_3 vi4_2_6_3 vi3_2_6_3 vi2_2_6_3 vi1_2_6_3 vi0_2_6_3 vo2_6_3) input_mux_8to1
CL2_6_3 (vo2_6_3 0) capacitor c=1p
save vo2_6_3 VDD2_6_3:p
VDD2_6_4 (vdsrc2_6_4 0) vsource dc=1.8
RVD2_6_4 (vdsrc2_6_4 vdd2_6_4) resistor r=50
VS0_2_6_4 (ss0_2_6_4 0) vsource dc=0
RS0_2_6_4 (ss0_2_6_4 s0_2_6_4) resistor r=50
VS1_2_6_4 (ss1_2_6_4 0) vsource dc=1.8
RS1_2_6_4 (ss1_2_6_4 s1_2_6_4) resistor r=50
VS2_2_6_4 (ss2_2_6_4 0) vsource dc=1.8
RS2_2_6_4 (ss2_2_6_4 s2_2_6_4) resistor r=50
VI0_2_6_4 (vs0_2_6_4 0) vsource dc=1.8 mag=0
RI0_2_6_4 (vs0_2_6_4 vi0_2_6_4) resistor r=50
VI1_2_6_4 (vs1_2_6_4 0) vsource dc=1.8 mag=0
RI1_2_6_4 (vs1_2_6_4 vi1_2_6_4) resistor r=50
VI2_2_6_4 (vs2_2_6_4 0) vsource dc=1.8 mag=0
RI2_2_6_4 (vs2_2_6_4 vi2_2_6_4) resistor r=50
VI3_2_6_4 (vs3_2_6_4 0) vsource dc=1.8 mag=0
RI3_2_6_4 (vs3_2_6_4 vi3_2_6_4) resistor r=50
VI4_2_6_4 (vs4_2_6_4 0) vsource dc=1.8 mag=1
RI4_2_6_4 (vs4_2_6_4 vi4_2_6_4) resistor r=50
VI5_2_6_4 (vs5_2_6_4 0) vsource dc=1.8 mag=0
RI5_2_6_4 (vs5_2_6_4 vi5_2_6_4) resistor r=50
VI6_2_6_4 (vs6_2_6_4 0) vsource dc=1.8 mag=0
RI6_2_6_4 (vs6_2_6_4 vi6_2_6_4) resistor r=50
VI7_2_6_4 (vs7_2_6_4 0) vsource dc=1.8 mag=0
RI7_2_6_4 (vs7_2_6_4 vi7_2_6_4) resistor r=50
X2_6_4 (vdd2_6_4 0 s2_2_6_4 s1_2_6_4 s0_2_6_4 vi7_2_6_4 vi6_2_6_4 vi5_2_6_4 vi4_2_6_4 vi3_2_6_4 vi2_2_6_4 vi1_2_6_4 vi0_2_6_4 vo2_6_4) input_mux_8to1
CL2_6_4 (vo2_6_4 0) capacitor c=1p
save vo2_6_4 VDD2_6_4:p
VDD2_6_5 (vdsrc2_6_5 0) vsource dc=1.8
RVD2_6_5 (vdsrc2_6_5 vdd2_6_5) resistor r=50
VS0_2_6_5 (ss0_2_6_5 0) vsource dc=0
RS0_2_6_5 (ss0_2_6_5 s0_2_6_5) resistor r=50
VS1_2_6_5 (ss1_2_6_5 0) vsource dc=1.8
RS1_2_6_5 (ss1_2_6_5 s1_2_6_5) resistor r=50
VS2_2_6_5 (ss2_2_6_5 0) vsource dc=1.8
RS2_2_6_5 (ss2_2_6_5 s2_2_6_5) resistor r=50
VI0_2_6_5 (vs0_2_6_5 0) vsource dc=1.8 mag=0
RI0_2_6_5 (vs0_2_6_5 vi0_2_6_5) resistor r=50
VI1_2_6_5 (vs1_2_6_5 0) vsource dc=1.8 mag=0
RI1_2_6_5 (vs1_2_6_5 vi1_2_6_5) resistor r=50
VI2_2_6_5 (vs2_2_6_5 0) vsource dc=1.8 mag=0
RI2_2_6_5 (vs2_2_6_5 vi2_2_6_5) resistor r=50
VI3_2_6_5 (vs3_2_6_5 0) vsource dc=1.8 mag=0
RI3_2_6_5 (vs3_2_6_5 vi3_2_6_5) resistor r=50
VI4_2_6_5 (vs4_2_6_5 0) vsource dc=1.8 mag=0
RI4_2_6_5 (vs4_2_6_5 vi4_2_6_5) resistor r=50
VI5_2_6_5 (vs5_2_6_5 0) vsource dc=1.8 mag=1
RI5_2_6_5 (vs5_2_6_5 vi5_2_6_5) resistor r=50
VI6_2_6_5 (vs6_2_6_5 0) vsource dc=1.8 mag=0
RI6_2_6_5 (vs6_2_6_5 vi6_2_6_5) resistor r=50
VI7_2_6_5 (vs7_2_6_5 0) vsource dc=1.8 mag=0
RI7_2_6_5 (vs7_2_6_5 vi7_2_6_5) resistor r=50
X2_6_5 (vdd2_6_5 0 s2_2_6_5 s1_2_6_5 s0_2_6_5 vi7_2_6_5 vi6_2_6_5 vi5_2_6_5 vi4_2_6_5 vi3_2_6_5 vi2_2_6_5 vi1_2_6_5 vi0_2_6_5 vo2_6_5) input_mux_8to1
CL2_6_5 (vo2_6_5 0) capacitor c=1p
save vo2_6_5 VDD2_6_5:p
VDD2_6_6 (vdsrc2_6_6 0) vsource dc=1.8
RVD2_6_6 (vdsrc2_6_6 vdd2_6_6) resistor r=50
VS0_2_6_6 (ss0_2_6_6 0) vsource dc=0
RS0_2_6_6 (ss0_2_6_6 s0_2_6_6) resistor r=50
VS1_2_6_6 (ss1_2_6_6 0) vsource dc=1.8
RS1_2_6_6 (ss1_2_6_6 s1_2_6_6) resistor r=50
VS2_2_6_6 (ss2_2_6_6 0) vsource dc=1.8
RS2_2_6_6 (ss2_2_6_6 s2_2_6_6) resistor r=50
VI0_2_6_6 (vs0_2_6_6 0) vsource dc=1.8 mag=0
RI0_2_6_6 (vs0_2_6_6 vi0_2_6_6) resistor r=50
VI1_2_6_6 (vs1_2_6_6 0) vsource dc=1.8 mag=0
RI1_2_6_6 (vs1_2_6_6 vi1_2_6_6) resistor r=50
VI2_2_6_6 (vs2_2_6_6 0) vsource dc=1.8 mag=0
RI2_2_6_6 (vs2_2_6_6 vi2_2_6_6) resistor r=50
VI3_2_6_6 (vs3_2_6_6 0) vsource dc=1.8 mag=0
RI3_2_6_6 (vs3_2_6_6 vi3_2_6_6) resistor r=50
VI4_2_6_6 (vs4_2_6_6 0) vsource dc=1.8 mag=0
RI4_2_6_6 (vs4_2_6_6 vi4_2_6_6) resistor r=50
VI5_2_6_6 (vs5_2_6_6 0) vsource dc=1.8 mag=0
RI5_2_6_6 (vs5_2_6_6 vi5_2_6_6) resistor r=50
VI6_2_6_6 (vs6_2_6_6 0) vsource dc=1.8 mag=1
RI6_2_6_6 (vs6_2_6_6 vi6_2_6_6) resistor r=50
VI7_2_6_6 (vs7_2_6_6 0) vsource dc=1.8 mag=0
RI7_2_6_6 (vs7_2_6_6 vi7_2_6_6) resistor r=50
X2_6_6 (vdd2_6_6 0 s2_2_6_6 s1_2_6_6 s0_2_6_6 vi7_2_6_6 vi6_2_6_6 vi5_2_6_6 vi4_2_6_6 vi3_2_6_6 vi2_2_6_6 vi1_2_6_6 vi0_2_6_6 vo2_6_6) input_mux_8to1
CL2_6_6 (vo2_6_6 0) capacitor c=1p
save vo2_6_6 VDD2_6_6:p
VDD2_6_7 (vdsrc2_6_7 0) vsource dc=1.8
RVD2_6_7 (vdsrc2_6_7 vdd2_6_7) resistor r=50
VS0_2_6_7 (ss0_2_6_7 0) vsource dc=0
RS0_2_6_7 (ss0_2_6_7 s0_2_6_7) resistor r=50
VS1_2_6_7 (ss1_2_6_7 0) vsource dc=1.8
RS1_2_6_7 (ss1_2_6_7 s1_2_6_7) resistor r=50
VS2_2_6_7 (ss2_2_6_7 0) vsource dc=1.8
RS2_2_6_7 (ss2_2_6_7 s2_2_6_7) resistor r=50
VI0_2_6_7 (vs0_2_6_7 0) vsource dc=1.8 mag=0
RI0_2_6_7 (vs0_2_6_7 vi0_2_6_7) resistor r=50
VI1_2_6_7 (vs1_2_6_7 0) vsource dc=1.8 mag=0
RI1_2_6_7 (vs1_2_6_7 vi1_2_6_7) resistor r=50
VI2_2_6_7 (vs2_2_6_7 0) vsource dc=1.8 mag=0
RI2_2_6_7 (vs2_2_6_7 vi2_2_6_7) resistor r=50
VI3_2_6_7 (vs3_2_6_7 0) vsource dc=1.8 mag=0
RI3_2_6_7 (vs3_2_6_7 vi3_2_6_7) resistor r=50
VI4_2_6_7 (vs4_2_6_7 0) vsource dc=1.8 mag=0
RI4_2_6_7 (vs4_2_6_7 vi4_2_6_7) resistor r=50
VI5_2_6_7 (vs5_2_6_7 0) vsource dc=1.8 mag=0
RI5_2_6_7 (vs5_2_6_7 vi5_2_6_7) resistor r=50
VI6_2_6_7 (vs6_2_6_7 0) vsource dc=1.8 mag=0
RI6_2_6_7 (vs6_2_6_7 vi6_2_6_7) resistor r=50
VI7_2_6_7 (vs7_2_6_7 0) vsource dc=1.8 mag=1
RI7_2_6_7 (vs7_2_6_7 vi7_2_6_7) resistor r=50
X2_6_7 (vdd2_6_7 0 s2_2_6_7 s1_2_6_7 s0_2_6_7 vi7_2_6_7 vi6_2_6_7 vi5_2_6_7 vi4_2_6_7 vi3_2_6_7 vi2_2_6_7 vi1_2_6_7 vi0_2_6_7 vo2_6_7) input_mux_8to1
CL2_6_7 (vo2_6_7 0) capacitor c=1p
save vo2_6_7 VDD2_6_7:p
VDD2_7_0 (vdsrc2_7_0 0) vsource dc=1.8
RVD2_7_0 (vdsrc2_7_0 vdd2_7_0) resistor r=50
VS0_2_7_0 (ss0_2_7_0 0) vsource dc=1.8
RS0_2_7_0 (ss0_2_7_0 s0_2_7_0) resistor r=50
VS1_2_7_0 (ss1_2_7_0 0) vsource dc=1.8
RS1_2_7_0 (ss1_2_7_0 s1_2_7_0) resistor r=50
VS2_2_7_0 (ss2_2_7_0 0) vsource dc=1.8
RS2_2_7_0 (ss2_2_7_0 s2_2_7_0) resistor r=50
VI0_2_7_0 (vs0_2_7_0 0) vsource dc=1.8 mag=1
RI0_2_7_0 (vs0_2_7_0 vi0_2_7_0) resistor r=50
VI1_2_7_0 (vs1_2_7_0 0) vsource dc=1.8 mag=0
RI1_2_7_0 (vs1_2_7_0 vi1_2_7_0) resistor r=50
VI2_2_7_0 (vs2_2_7_0 0) vsource dc=1.8 mag=0
RI2_2_7_0 (vs2_2_7_0 vi2_2_7_0) resistor r=50
VI3_2_7_0 (vs3_2_7_0 0) vsource dc=1.8 mag=0
RI3_2_7_0 (vs3_2_7_0 vi3_2_7_0) resistor r=50
VI4_2_7_0 (vs4_2_7_0 0) vsource dc=1.8 mag=0
RI4_2_7_0 (vs4_2_7_0 vi4_2_7_0) resistor r=50
VI5_2_7_0 (vs5_2_7_0 0) vsource dc=1.8 mag=0
RI5_2_7_0 (vs5_2_7_0 vi5_2_7_0) resistor r=50
VI6_2_7_0 (vs6_2_7_0 0) vsource dc=1.8 mag=0
RI6_2_7_0 (vs6_2_7_0 vi6_2_7_0) resistor r=50
VI7_2_7_0 (vs7_2_7_0 0) vsource dc=1.8 mag=0
RI7_2_7_0 (vs7_2_7_0 vi7_2_7_0) resistor r=50
X2_7_0 (vdd2_7_0 0 s2_2_7_0 s1_2_7_0 s0_2_7_0 vi7_2_7_0 vi6_2_7_0 vi5_2_7_0 vi4_2_7_0 vi3_2_7_0 vi2_2_7_0 vi1_2_7_0 vi0_2_7_0 vo2_7_0) input_mux_8to1
CL2_7_0 (vo2_7_0 0) capacitor c=1p
save vo2_7_0 VDD2_7_0:p
VDD2_7_1 (vdsrc2_7_1 0) vsource dc=1.8
RVD2_7_1 (vdsrc2_7_1 vdd2_7_1) resistor r=50
VS0_2_7_1 (ss0_2_7_1 0) vsource dc=1.8
RS0_2_7_1 (ss0_2_7_1 s0_2_7_1) resistor r=50
VS1_2_7_1 (ss1_2_7_1 0) vsource dc=1.8
RS1_2_7_1 (ss1_2_7_1 s1_2_7_1) resistor r=50
VS2_2_7_1 (ss2_2_7_1 0) vsource dc=1.8
RS2_2_7_1 (ss2_2_7_1 s2_2_7_1) resistor r=50
VI0_2_7_1 (vs0_2_7_1 0) vsource dc=1.8 mag=0
RI0_2_7_1 (vs0_2_7_1 vi0_2_7_1) resistor r=50
VI1_2_7_1 (vs1_2_7_1 0) vsource dc=1.8 mag=1
RI1_2_7_1 (vs1_2_7_1 vi1_2_7_1) resistor r=50
VI2_2_7_1 (vs2_2_7_1 0) vsource dc=1.8 mag=0
RI2_2_7_1 (vs2_2_7_1 vi2_2_7_1) resistor r=50
VI3_2_7_1 (vs3_2_7_1 0) vsource dc=1.8 mag=0
RI3_2_7_1 (vs3_2_7_1 vi3_2_7_1) resistor r=50
VI4_2_7_1 (vs4_2_7_1 0) vsource dc=1.8 mag=0
RI4_2_7_1 (vs4_2_7_1 vi4_2_7_1) resistor r=50
VI5_2_7_1 (vs5_2_7_1 0) vsource dc=1.8 mag=0
RI5_2_7_1 (vs5_2_7_1 vi5_2_7_1) resistor r=50
VI6_2_7_1 (vs6_2_7_1 0) vsource dc=1.8 mag=0
RI6_2_7_1 (vs6_2_7_1 vi6_2_7_1) resistor r=50
VI7_2_7_1 (vs7_2_7_1 0) vsource dc=1.8 mag=0
RI7_2_7_1 (vs7_2_7_1 vi7_2_7_1) resistor r=50
X2_7_1 (vdd2_7_1 0 s2_2_7_1 s1_2_7_1 s0_2_7_1 vi7_2_7_1 vi6_2_7_1 vi5_2_7_1 vi4_2_7_1 vi3_2_7_1 vi2_2_7_1 vi1_2_7_1 vi0_2_7_1 vo2_7_1) input_mux_8to1
CL2_7_1 (vo2_7_1 0) capacitor c=1p
save vo2_7_1 VDD2_7_1:p
VDD2_7_2 (vdsrc2_7_2 0) vsource dc=1.8
RVD2_7_2 (vdsrc2_7_2 vdd2_7_2) resistor r=50
VS0_2_7_2 (ss0_2_7_2 0) vsource dc=1.8
RS0_2_7_2 (ss0_2_7_2 s0_2_7_2) resistor r=50
VS1_2_7_2 (ss1_2_7_2 0) vsource dc=1.8
RS1_2_7_2 (ss1_2_7_2 s1_2_7_2) resistor r=50
VS2_2_7_2 (ss2_2_7_2 0) vsource dc=1.8
RS2_2_7_2 (ss2_2_7_2 s2_2_7_2) resistor r=50
VI0_2_7_2 (vs0_2_7_2 0) vsource dc=1.8 mag=0
RI0_2_7_2 (vs0_2_7_2 vi0_2_7_2) resistor r=50
VI1_2_7_2 (vs1_2_7_2 0) vsource dc=1.8 mag=0
RI1_2_7_2 (vs1_2_7_2 vi1_2_7_2) resistor r=50
VI2_2_7_2 (vs2_2_7_2 0) vsource dc=1.8 mag=1
RI2_2_7_2 (vs2_2_7_2 vi2_2_7_2) resistor r=50
VI3_2_7_2 (vs3_2_7_2 0) vsource dc=1.8 mag=0
RI3_2_7_2 (vs3_2_7_2 vi3_2_7_2) resistor r=50
VI4_2_7_2 (vs4_2_7_2 0) vsource dc=1.8 mag=0
RI4_2_7_2 (vs4_2_7_2 vi4_2_7_2) resistor r=50
VI5_2_7_2 (vs5_2_7_2 0) vsource dc=1.8 mag=0
RI5_2_7_2 (vs5_2_7_2 vi5_2_7_2) resistor r=50
VI6_2_7_2 (vs6_2_7_2 0) vsource dc=1.8 mag=0
RI6_2_7_2 (vs6_2_7_2 vi6_2_7_2) resistor r=50
VI7_2_7_2 (vs7_2_7_2 0) vsource dc=1.8 mag=0
RI7_2_7_2 (vs7_2_7_2 vi7_2_7_2) resistor r=50
X2_7_2 (vdd2_7_2 0 s2_2_7_2 s1_2_7_2 s0_2_7_2 vi7_2_7_2 vi6_2_7_2 vi5_2_7_2 vi4_2_7_2 vi3_2_7_2 vi2_2_7_2 vi1_2_7_2 vi0_2_7_2 vo2_7_2) input_mux_8to1
CL2_7_2 (vo2_7_2 0) capacitor c=1p
save vo2_7_2 VDD2_7_2:p
VDD2_7_3 (vdsrc2_7_3 0) vsource dc=1.8
RVD2_7_3 (vdsrc2_7_3 vdd2_7_3) resistor r=50
VS0_2_7_3 (ss0_2_7_3 0) vsource dc=1.8
RS0_2_7_3 (ss0_2_7_3 s0_2_7_3) resistor r=50
VS1_2_7_3 (ss1_2_7_3 0) vsource dc=1.8
RS1_2_7_3 (ss1_2_7_3 s1_2_7_3) resistor r=50
VS2_2_7_3 (ss2_2_7_3 0) vsource dc=1.8
RS2_2_7_3 (ss2_2_7_3 s2_2_7_3) resistor r=50
VI0_2_7_3 (vs0_2_7_3 0) vsource dc=1.8 mag=0
RI0_2_7_3 (vs0_2_7_3 vi0_2_7_3) resistor r=50
VI1_2_7_3 (vs1_2_7_3 0) vsource dc=1.8 mag=0
RI1_2_7_3 (vs1_2_7_3 vi1_2_7_3) resistor r=50
VI2_2_7_3 (vs2_2_7_3 0) vsource dc=1.8 mag=0
RI2_2_7_3 (vs2_2_7_3 vi2_2_7_3) resistor r=50
VI3_2_7_3 (vs3_2_7_3 0) vsource dc=1.8 mag=1
RI3_2_7_3 (vs3_2_7_3 vi3_2_7_3) resistor r=50
VI4_2_7_3 (vs4_2_7_3 0) vsource dc=1.8 mag=0
RI4_2_7_3 (vs4_2_7_3 vi4_2_7_3) resistor r=50
VI5_2_7_3 (vs5_2_7_3 0) vsource dc=1.8 mag=0
RI5_2_7_3 (vs5_2_7_3 vi5_2_7_3) resistor r=50
VI6_2_7_3 (vs6_2_7_3 0) vsource dc=1.8 mag=0
RI6_2_7_3 (vs6_2_7_3 vi6_2_7_3) resistor r=50
VI7_2_7_3 (vs7_2_7_3 0) vsource dc=1.8 mag=0
RI7_2_7_3 (vs7_2_7_3 vi7_2_7_3) resistor r=50
X2_7_3 (vdd2_7_3 0 s2_2_7_3 s1_2_7_3 s0_2_7_3 vi7_2_7_3 vi6_2_7_3 vi5_2_7_3 vi4_2_7_3 vi3_2_7_3 vi2_2_7_3 vi1_2_7_3 vi0_2_7_3 vo2_7_3) input_mux_8to1
CL2_7_3 (vo2_7_3 0) capacitor c=1p
save vo2_7_3 VDD2_7_3:p
VDD2_7_4 (vdsrc2_7_4 0) vsource dc=1.8
RVD2_7_4 (vdsrc2_7_4 vdd2_7_4) resistor r=50
VS0_2_7_4 (ss0_2_7_4 0) vsource dc=1.8
RS0_2_7_4 (ss0_2_7_4 s0_2_7_4) resistor r=50
VS1_2_7_4 (ss1_2_7_4 0) vsource dc=1.8
RS1_2_7_4 (ss1_2_7_4 s1_2_7_4) resistor r=50
VS2_2_7_4 (ss2_2_7_4 0) vsource dc=1.8
RS2_2_7_4 (ss2_2_7_4 s2_2_7_4) resistor r=50
VI0_2_7_4 (vs0_2_7_4 0) vsource dc=1.8 mag=0
RI0_2_7_4 (vs0_2_7_4 vi0_2_7_4) resistor r=50
VI1_2_7_4 (vs1_2_7_4 0) vsource dc=1.8 mag=0
RI1_2_7_4 (vs1_2_7_4 vi1_2_7_4) resistor r=50
VI2_2_7_4 (vs2_2_7_4 0) vsource dc=1.8 mag=0
RI2_2_7_4 (vs2_2_7_4 vi2_2_7_4) resistor r=50
VI3_2_7_4 (vs3_2_7_4 0) vsource dc=1.8 mag=0
RI3_2_7_4 (vs3_2_7_4 vi3_2_7_4) resistor r=50
VI4_2_7_4 (vs4_2_7_4 0) vsource dc=1.8 mag=1
RI4_2_7_4 (vs4_2_7_4 vi4_2_7_4) resistor r=50
VI5_2_7_4 (vs5_2_7_4 0) vsource dc=1.8 mag=0
RI5_2_7_4 (vs5_2_7_4 vi5_2_7_4) resistor r=50
VI6_2_7_4 (vs6_2_7_4 0) vsource dc=1.8 mag=0
RI6_2_7_4 (vs6_2_7_4 vi6_2_7_4) resistor r=50
VI7_2_7_4 (vs7_2_7_4 0) vsource dc=1.8 mag=0
RI7_2_7_4 (vs7_2_7_4 vi7_2_7_4) resistor r=50
X2_7_4 (vdd2_7_4 0 s2_2_7_4 s1_2_7_4 s0_2_7_4 vi7_2_7_4 vi6_2_7_4 vi5_2_7_4 vi4_2_7_4 vi3_2_7_4 vi2_2_7_4 vi1_2_7_4 vi0_2_7_4 vo2_7_4) input_mux_8to1
CL2_7_4 (vo2_7_4 0) capacitor c=1p
save vo2_7_4 VDD2_7_4:p
VDD2_7_5 (vdsrc2_7_5 0) vsource dc=1.8
RVD2_7_5 (vdsrc2_7_5 vdd2_7_5) resistor r=50
VS0_2_7_5 (ss0_2_7_5 0) vsource dc=1.8
RS0_2_7_5 (ss0_2_7_5 s0_2_7_5) resistor r=50
VS1_2_7_5 (ss1_2_7_5 0) vsource dc=1.8
RS1_2_7_5 (ss1_2_7_5 s1_2_7_5) resistor r=50
VS2_2_7_5 (ss2_2_7_5 0) vsource dc=1.8
RS2_2_7_5 (ss2_2_7_5 s2_2_7_5) resistor r=50
VI0_2_7_5 (vs0_2_7_5 0) vsource dc=1.8 mag=0
RI0_2_7_5 (vs0_2_7_5 vi0_2_7_5) resistor r=50
VI1_2_7_5 (vs1_2_7_5 0) vsource dc=1.8 mag=0
RI1_2_7_5 (vs1_2_7_5 vi1_2_7_5) resistor r=50
VI2_2_7_5 (vs2_2_7_5 0) vsource dc=1.8 mag=0
RI2_2_7_5 (vs2_2_7_5 vi2_2_7_5) resistor r=50
VI3_2_7_5 (vs3_2_7_5 0) vsource dc=1.8 mag=0
RI3_2_7_5 (vs3_2_7_5 vi3_2_7_5) resistor r=50
VI4_2_7_5 (vs4_2_7_5 0) vsource dc=1.8 mag=0
RI4_2_7_5 (vs4_2_7_5 vi4_2_7_5) resistor r=50
VI5_2_7_5 (vs5_2_7_5 0) vsource dc=1.8 mag=1
RI5_2_7_5 (vs5_2_7_5 vi5_2_7_5) resistor r=50
VI6_2_7_5 (vs6_2_7_5 0) vsource dc=1.8 mag=0
RI6_2_7_5 (vs6_2_7_5 vi6_2_7_5) resistor r=50
VI7_2_7_5 (vs7_2_7_5 0) vsource dc=1.8 mag=0
RI7_2_7_5 (vs7_2_7_5 vi7_2_7_5) resistor r=50
X2_7_5 (vdd2_7_5 0 s2_2_7_5 s1_2_7_5 s0_2_7_5 vi7_2_7_5 vi6_2_7_5 vi5_2_7_5 vi4_2_7_5 vi3_2_7_5 vi2_2_7_5 vi1_2_7_5 vi0_2_7_5 vo2_7_5) input_mux_8to1
CL2_7_5 (vo2_7_5 0) capacitor c=1p
save vo2_7_5 VDD2_7_5:p
VDD2_7_6 (vdsrc2_7_6 0) vsource dc=1.8
RVD2_7_6 (vdsrc2_7_6 vdd2_7_6) resistor r=50
VS0_2_7_6 (ss0_2_7_6 0) vsource dc=1.8
RS0_2_7_6 (ss0_2_7_6 s0_2_7_6) resistor r=50
VS1_2_7_6 (ss1_2_7_6 0) vsource dc=1.8
RS1_2_7_6 (ss1_2_7_6 s1_2_7_6) resistor r=50
VS2_2_7_6 (ss2_2_7_6 0) vsource dc=1.8
RS2_2_7_6 (ss2_2_7_6 s2_2_7_6) resistor r=50
VI0_2_7_6 (vs0_2_7_6 0) vsource dc=1.8 mag=0
RI0_2_7_6 (vs0_2_7_6 vi0_2_7_6) resistor r=50
VI1_2_7_6 (vs1_2_7_6 0) vsource dc=1.8 mag=0
RI1_2_7_6 (vs1_2_7_6 vi1_2_7_6) resistor r=50
VI2_2_7_6 (vs2_2_7_6 0) vsource dc=1.8 mag=0
RI2_2_7_6 (vs2_2_7_6 vi2_2_7_6) resistor r=50
VI3_2_7_6 (vs3_2_7_6 0) vsource dc=1.8 mag=0
RI3_2_7_6 (vs3_2_7_6 vi3_2_7_6) resistor r=50
VI4_2_7_6 (vs4_2_7_6 0) vsource dc=1.8 mag=0
RI4_2_7_6 (vs4_2_7_6 vi4_2_7_6) resistor r=50
VI5_2_7_6 (vs5_2_7_6 0) vsource dc=1.8 mag=0
RI5_2_7_6 (vs5_2_7_6 vi5_2_7_6) resistor r=50
VI6_2_7_6 (vs6_2_7_6 0) vsource dc=1.8 mag=1
RI6_2_7_6 (vs6_2_7_6 vi6_2_7_6) resistor r=50
VI7_2_7_6 (vs7_2_7_6 0) vsource dc=1.8 mag=0
RI7_2_7_6 (vs7_2_7_6 vi7_2_7_6) resistor r=50
X2_7_6 (vdd2_7_6 0 s2_2_7_6 s1_2_7_6 s0_2_7_6 vi7_2_7_6 vi6_2_7_6 vi5_2_7_6 vi4_2_7_6 vi3_2_7_6 vi2_2_7_6 vi1_2_7_6 vi0_2_7_6 vo2_7_6) input_mux_8to1
CL2_7_6 (vo2_7_6 0) capacitor c=1p
save vo2_7_6 VDD2_7_6:p
VDD2_7_7 (vdsrc2_7_7 0) vsource dc=1.8
RVD2_7_7 (vdsrc2_7_7 vdd2_7_7) resistor r=50
VS0_2_7_7 (ss0_2_7_7 0) vsource dc=1.8
RS0_2_7_7 (ss0_2_7_7 s0_2_7_7) resistor r=50
VS1_2_7_7 (ss1_2_7_7 0) vsource dc=1.8
RS1_2_7_7 (ss1_2_7_7 s1_2_7_7) resistor r=50
VS2_2_7_7 (ss2_2_7_7 0) vsource dc=1.8
RS2_2_7_7 (ss2_2_7_7 s2_2_7_7) resistor r=50
VI0_2_7_7 (vs0_2_7_7 0) vsource dc=1.8 mag=0
RI0_2_7_7 (vs0_2_7_7 vi0_2_7_7) resistor r=50
VI1_2_7_7 (vs1_2_7_7 0) vsource dc=1.8 mag=0
RI1_2_7_7 (vs1_2_7_7 vi1_2_7_7) resistor r=50
VI2_2_7_7 (vs2_2_7_7 0) vsource dc=1.8 mag=0
RI2_2_7_7 (vs2_2_7_7 vi2_2_7_7) resistor r=50
VI3_2_7_7 (vs3_2_7_7 0) vsource dc=1.8 mag=0
RI3_2_7_7 (vs3_2_7_7 vi3_2_7_7) resistor r=50
VI4_2_7_7 (vs4_2_7_7 0) vsource dc=1.8 mag=0
RI4_2_7_7 (vs4_2_7_7 vi4_2_7_7) resistor r=50
VI5_2_7_7 (vs5_2_7_7 0) vsource dc=1.8 mag=0
RI5_2_7_7 (vs5_2_7_7 vi5_2_7_7) resistor r=50
VI6_2_7_7 (vs6_2_7_7 0) vsource dc=1.8 mag=0
RI6_2_7_7 (vs6_2_7_7 vi6_2_7_7) resistor r=50
VI7_2_7_7 (vs7_2_7_7 0) vsource dc=1.8 mag=1
RI7_2_7_7 (vs7_2_7_7 vi7_2_7_7) resistor r=50
X2_7_7 (vdd2_7_7 0 s2_2_7_7 s1_2_7_7 s0_2_7_7 vi7_2_7_7 vi6_2_7_7 vi5_2_7_7 vi4_2_7_7 vi3_2_7_7 vi2_2_7_7 vi1_2_7_7 vi0_2_7_7 vo2_7_7) input_mux_8to1
CL2_7_7 (vo2_7_7 0) capacitor c=1p
save vo2_7_7 VDD2_7_7:p
dcOp dc
ac ac start=1m stop=1G dec=60
