simulator lang=spectre
global 0
include "/home/IC/Tech/smic_018mmrf-OA/SMIC_018_MMRF/models/spectre/ms018_v1p7_spe.lib" section=tt
include "/home/IC/CodeX/smic18_benchmark_repro/runs/31/20260922T093040811547Z_fft/inputs/circuit.scs"
simulatorOptions options temp=27 tnom=27 reltol=2e-06 vabstol=1e-9 iabstol=1e-12
saveOptions options save=selected
include "/home/IC/CodeX/smic18_benchmark_repro/runs/31/20260922T093040811547Z_fft/inputs/hd_cells.scs"
VDDS (vddS 0) vsource dc=1.8
VCMS (vcmS 0) vsource dc=.9
VCLKS (clk_srcS 0) vsource type=pwl wave=[0 0 2e-09 0 2.05e-09 1.8 7.05e-09 1.8 7.1e-09 0 1.2e-08 0 1.205e-08 1.8 1.705e-08 1.8 1.71e-08 0 2.2e-08 0 2.205e-08 1.8 2.705e-08 1.8 2.71e-08 0 3.2e-08 0 3.205e-08 1.8 3.705e-08 1.8 3.71e-08 0 4.2e-08 0 4.205e-08 1.8 4.705e-08 1.8 4.71e-08 0 5.2e-08 0 5.205e-08 1.8 5.705e-08 1.8 5.71e-08 0 6.2e-08 0 6.205e-08 1.8 6.705e-08 1.8 6.71e-08 0 7.2e-08 0 7.205e-08 1.8 7.705e-08 1.8 7.71e-08 0 8.2e-08 0 8.205e-08 1.8 8.705e-08 1.8 8.71e-08 0 9.2e-08 0 9.205e-08 1.8 9.705e-08 1.8 9.71e-08 0 1.02e-07 0 1.0205e-07 1.8 1.0705e-07 1.8 1.071e-07 0 1.12e-07 0 1.1205e-07 1.8 1.1705e-07 1.8 1.171e-07 0 1.22e-07 0 1.2205e-07 1.8 1.2705e-07 1.8 1.271e-07 0 1.32e-07 0 1.3205e-07 1.8 1.3705e-07 1.8 1.371e-07 0 1.42e-07 0 1.4205e-07 1.8 1.4705e-07 1.8 1.471e-07 0 1.52e-07 0 1.5205e-07 1.8 1.5705e-07 1.8 1.571e-07 0 1.62e-07 0 1.6205e-07 1.8 1.6705e-07 1.8 1.671e-07 0 1.72e-07 0 1.7205e-07 1.8 1.7705e-07 1.8 1.771e-07 0 1.82e-07 0 1.8205e-07 1.8 1.8705e-07 1.8 1.871e-07 0 1.92e-07 0 1.9205e-07 1.8 1.9705e-07 1.8 1.971e-07 0 2.02e-07 0 2.0205e-07 1.8 2.0705e-07 1.8 2.071e-07 0 2.12e-07 0 2.1205e-07 1.8 2.1705e-07 1.8 2.171e-07 0 2.22e-07 0 2.2205e-07 1.8 2.2705e-07 1.8 2.271e-07 0 2.32e-07 0 2.3205e-07 1.8 2.3705e-07 1.8 2.371e-07 0 2.42e-07 0 2.4205e-07 1.8 2.4705e-07 1.8 2.471e-07 0 2.52e-07 0 2.5205e-07 1.8 2.5705e-07 1.8 2.571e-07 0 2.62e-07 0 2.6205e-07 1.8 2.6705e-07 1.8 2.671e-07 0 2.72e-07 0 2.7205e-07 1.8 2.7705e-07 1.8 2.771e-07 0 2.82e-07 0 2.8205e-07 1.8 2.8705e-07 1.8 2.871e-07 0 2.92e-07 0 2.9205e-07 1.8 2.9705e-07 1.8 2.971e-07 0 3.02e-07 0 3.0205e-07 1.8 3.0705e-07 1.8 3.071e-07 0 3.12e-07 0 3.1205e-07 1.8 3.1705e-07 1.8 3.171e-07 0 3.22e-07 0 3.2205e-07 1.8 3.2705e-07 1.8 3.271e-07 0 3.32e-07 0 3.3205e-07 1.8 3.3705e-07 1.8 3.371e-07 0 3.42e-07 0 3.4205e-07 1.8 3.4705e-07 1.8 3.471e-07 0 3.52e-07 0 3.5205e-07 1.8 3.5705e-07 1.8 3.571e-07 0 3.62e-07 0 3.6205e-07 1.8 3.6705e-07 1.8 3.671e-07 0 3.72e-07 0 3.7205e-07 1.8 3.7705e-07 1.8 3.771e-07 0 3.82e-07 0 3.8205e-07 1.8 3.8705e-07 1.8 3.871e-07 0 3.92e-07 0 3.9205e-07 1.8 3.9705e-07 1.8 3.971e-07 0 4.02e-07 0 4.0205e-07 1.8 4.0705e-07 1.8 4.071e-07 0 4.12e-07 0 4.1205e-07 1.8 4.1705e-07 1.8 4.171e-07 0 4.22e-07 0 4.2205e-07 1.8 4.2705e-07 1.8 4.271e-07 0 4.32e-07 0 4.3205e-07 1.8 4.3705e-07 1.8 4.371e-07 0 4.42e-07 0 4.4205e-07 1.8 4.4705e-07 1.8 4.471e-07 0 4.52e-07 0 4.5205e-07 1.8 4.5705e-07 1.8 4.571e-07 0 4.62e-07 0 4.6205e-07 1.8 4.6705e-07 1.8 4.671e-07 0 4.72e-07 0 4.7205e-07 1.8 4.7705e-07 1.8 4.771e-07 0 4.82e-07 0 4.8205e-07 1.8 4.8705e-07 1.8 4.871e-07 0 4.92e-07 0 4.9205e-07 1.8 4.9705e-07 1.8 4.971e-07 0 5.02e-07 0 5.0205e-07 1.8 5.0705e-07 1.8 5.071e-07 0 5.12e-07 0 5.1205e-07 1.8 5.1705e-07 1.8 5.171e-07 0 5.22e-07 0 5.2205e-07 1.8 5.2705e-07 1.8 5.271e-07 0 5.32e-07 0 5.3205e-07 1.8 5.3705e-07 1.8 5.371e-07 0 5.42e-07 0 5.4205e-07 1.8 5.4705e-07 1.8 5.471e-07 0 5.52e-07 0 5.5205e-07 1.8 5.5705e-07 1.8 5.571e-07 0 5.62e-07 0 5.6205e-07 1.8 5.6705e-07 1.8 5.671e-07 0 5.72e-07 0 5.7205e-07 1.8 5.7705e-07 1.8 5.771e-07 0 5.82e-07 0 5.8205e-07 1.8 5.8705e-07 1.8 5.871e-07 0 5.92e-07 0 5.9205e-07 1.8 5.9705e-07 1.8 5.971e-07 0 6.02e-07 0 6.0205e-07 1.8 6.0705e-07 1.8 6.071e-07 0 6.12e-07 0 6.1205e-07 1.8 6.1705e-07 1.8 6.171e-07 0 6.22e-07 0 6.2205e-07 1.8 6.2705e-07 1.8 6.271e-07 0 6.32e-07 0 6.3205e-07 1.8 6.3705e-07 1.8 6.371e-07 0 6.42e-07 0 6.4205e-07 1.8 6.4705e-07 1.8 6.471e-07 0 6.52e-07 0 6.5205e-07 1.8 6.5705e-07 1.8 6.571e-07 0 6.62e-07 0 6.6205e-07 1.8 6.6705e-07 1.8 6.671e-07 0 6.72e-07 0 6.7205e-07 1.8 6.7705e-07 1.8 6.771e-07 0 6.82e-07 0 6.8205e-07 1.8 6.8705e-07 1.8 6.871e-07 0 6.92e-07 0 6.9205e-07 1.8 6.9705e-07 1.8 6.971e-07 0 7.02e-07 0 7.0205e-07 1.8 7.0705e-07 1.8 7.071e-07 0 7.12e-07 0 7.1205e-07 1.8 7.1705e-07 1.8 7.171e-07 0 7.22e-07 0 7.2205e-07 1.8 7.2705e-07 1.8 7.271e-07 0 7.32e-07 0 7.3205e-07 1.8 7.3705e-07 1.8 7.371e-07 0 7.42e-07 0 7.4205e-07 1.8 7.4705e-07 1.8 7.471e-07 0 7.52e-07 0 7.5205e-07 1.8 7.5705e-07 1.8 7.571e-07 0 7.62e-07 0 7.6205e-07 1.8 7.6705e-07 1.8 7.671e-07 0 7.72e-07 0 7.7205e-07 1.8 7.7705e-07 1.8 7.771e-07 0 7.82e-07 0 7.8205e-07 1.8 7.8705e-07 1.8 7.871e-07 0 7.92e-07 0 7.9205e-07 1.8 7.9705e-07 1.8 7.971e-07 0 8.02e-07 0 8.0205e-07 1.8 8.0705e-07 1.8 8.071e-07 0 8.12e-07 0 8.1205e-07 1.8 8.1705e-07 1.8 8.171e-07 0 8.22e-07 0 8.2205e-07 1.8 8.2705e-07 1.8 8.271e-07 0 8.32e-07 0 8.3205e-07 1.8 8.3705e-07 1.8 8.371e-07 0 8.42e-07 0 8.4205e-07 1.8 8.4705e-07 1.8 8.471e-07 0 8.52e-07 0 8.5205e-07 1.8 8.5705e-07 1.8 8.571e-07 0 8.62e-07 0 8.6205e-07 1.8 8.6705e-07 1.8 8.671e-07 0 8.72e-07 0 8.7205e-07 1.8 8.7705e-07 1.8 8.771e-07 0 8.82e-07 0 8.8205e-07 1.8 8.8705e-07 1.8 8.871e-07 0 8.92e-07 0 8.9205e-07 1.8 8.9705e-07 1.8 8.971e-07 0 9e-07 0]
RCLKS (clk_srcS clkS) resistor r=50
VINPS (vinpS 0) vsource type=sine dc=.9 ampl=0.4 freq=5M
VINNS (vinnS 0) vsource type=sine dc=.9 ampl=-0.4 freq=5M
XS (vinpS vinnS clkS vcmS vddS 0 vspS vsnS vtoppS vtopnS) bottom_plate_sampler
save vinpS vinnS clkS clk_srcS vcmS vspS vsnS vtoppS vtopnS
save VDDS:p VCMS:p VINPS:p VINNS:p VCLKS:p
save XS.early XS.earlyb XS.late XS.lateb
save XS.vgp XS.vgn XS.vgc
save XS.XBP.CBT XS.XBP.CBB XS.XBP.CG XS.XBP.CLKP XS.XBP.CLKN
save XS.XBN.CBT XS.XBN.CBB XS.XBN.CG XS.XBN.CLKP XS.XBN.CLKN
save XS.XBC.CBT XS.XBC.CBB XS.XBC.CG XS.XBC.CLKP XS.XBC.CLKN
save XS.XBP.PRE XS.XBN.PRE XS.XBC.PRE
tran tran stop=900n maxstep=2.5p errpreset=conservative
