simulator lang=spectre
global 0
include "/home/IC/Tech/smic_018mmrf-OA/SMIC_018_MMRF/models/spectre/ms018_v1p7_spe.lib" section=tt
include "/home/IC/CodeX/smic18_benchmark_repro/runs/42/20260929T040646785524Z_transfer_alt1/inputs/hd_cells.scs"
include "/home/IC/CodeX/smic18_benchmark_repro/runs/42/20260929T040646785524Z_transfer_alt1/inputs/circuit.scs"
VDD (vdd 0) vsource dc=1.8
VREFP (vrefp 0) vsource dc=1.8
VCLKS (clks_src 0) vsource type=pulse val0=0 val1=1.8 delay=1p rise=20p fall=20p width=1.98n period=10n
RCLKS (clks_src clks) resistor r=50
X (clks d5 d4 d3 d2 d1 d0 0 vdd vinn vinp 0 vrefp) sar_adc_6bit_async
simulatorOptions options temp=27 tnom=27 reltol=1e-06 vabstol=1e-8 iabstol=1e-14 gmin=1e-15
saveOptions options save=selected
save clks_src clks vinp vinn vcm d0 d1 d2 d3 d4 d5 VDD:p VREFP:p VINP:p VINN:p VCLKS:p
C0 (d0 0) capacitor c=10f
C1 (d1 0) capacitor c=10f
C2 (d2 0) capacitor c=10f
C3 (d3 0) capacitor c=10f
C4 (d4 0) capacitor c=10f
C5 (d5 0) capacitor c=10f
VINP (vinp 0) vsource type=pwl wave=[0n 1.1953125 2.2n 1.1953125 2.25n 1.6734375 9.25n 1.6734375 9.3n 1.7859375 12.2n 1.7859375 12.25n 0.4640625 19.25n 0.4640625 19.3n 0.5765625 22.2n 0.5765625 22.25n 1.0546875 29.25n 1.0546875 29.3n 1.1671875 32.2n 1.1671875 32.25n 1.6453125 39.25n 1.6453125 39.3n 1.7578125 42.2n 1.7578125 42.25n 0.4359375 49.25n 0.4359375 49.3n 0.5484375 52.2n 0.5484375 52.25n 1.0265625 59.25n 1.0265625 59.3n 1.1390625 62.2n 1.1390625 62.25n 1.6171875 69.25n 1.6171875 69.3n 1.7296875 72.2n 1.7296875 72.25n 0.4078125 79.25n 0.4078125 79.3n 0.5203125 82.2n 0.5203125 82.25n 0.9984375 89.25n 0.9984375 89.3n 1.1109375 92.2n 1.1109375 92.25n 1.5890625 99.25n 1.5890625 99.3n 1.7015625 102.2n 1.7015625 102.25n 0.3796875 109.25n 0.3796875 109.3n 0.4921875 112.2n 0.4921875 112.25n 0.9703125 119.25n 0.9703125 119.3n 1.0828125 122.2n 1.0828125 122.25n 1.5609375 129.25n 1.5609375 129.3n 1.6734375 132.2n 1.6734375 132.25n 0.3515625 139.25n 0.3515625 139.3n 0.4640625 142.2n 0.4640625 142.25n 0.9421875 149.25n 0.9421875 149.3n 1.0546875 152.2n 1.0546875 152.25n 1.5328125 159.25n 1.5328125 159.3n 1.6453125 162.2n 1.6453125 162.25n 0.3234375]
VINN (vinn 0) vsource type=pwl wave=[0n 0.6046875 2.2n 0.6046875 2.25n 0.1265625 9.25n 0.1265625 9.3n 0.0140625 12.2n 0.0140625 12.25n 1.3359375 19.25n 1.3359375 19.3n 1.2234375 22.2n 1.2234375 22.25n 0.7453125 29.25n 0.7453125 29.3n 0.6328125 32.2n 0.6328125 32.25n 0.1546875 39.25n 0.1546875 39.3n 0.0421875 42.2n 0.0421875 42.25n 1.3640625 49.25n 1.3640625 49.3n 1.2515625 52.2n 1.2515625 52.25n 0.7734375 59.25n 0.7734375 59.3n 0.6609375 62.2n 0.6609375 62.25n 0.1828125 69.25n 0.1828125 69.3n 0.0703125 72.2n 0.0703125 72.25n 1.3921875 79.25n 1.3921875 79.3n 1.2796875 82.2n 1.2796875 82.25n 0.8015625 89.25n 0.8015625 89.3n 0.6890625 92.2n 0.6890625 92.25n 0.2109375 99.25n 0.2109375 99.3n 0.0984375 102.2n 0.0984375 102.25n 1.4203125 109.25n 1.4203125 109.3n 1.3078125 112.2n 1.3078125 112.25n 0.8296875 119.25n 0.8296875 119.3n 0.7171875 122.2n 0.7171875 122.25n 0.2390625 129.25n 0.2390625 129.3n 0.1265625 132.2n 0.1265625 132.25n 1.4484375 139.25n 1.4484375 139.3n 1.3359375 142.2n 1.3359375 142.25n 0.8578125 149.25n 0.8578125 149.3n 0.7453125 152.2n 0.7453125 152.25n 0.2671875 159.25n 0.2671875 159.3n 0.1546875 162.2n 0.1546875 162.25n 1.4765625]
VCM (vcm 0) vsource dc=.9
tran tran stop=1.695e-07 maxstep=2.5e-11 method=gear2only errpreset=conservative
