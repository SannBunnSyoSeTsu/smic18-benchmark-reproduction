simulator lang=spectre
global 0
include "/home/IC/Tech/smic_018mmrf-OA/SMIC_018_MMRF/models/spectre/ms018_v1p7_spe.lib" section=tt
include "/home/IC/CodeX/smic18_benchmark_repro/runs/13/20260922T072020462547Z_static/inputs/circuit.scs"
simulatorOptions options temp=27 tnom=27 reltol=1e-6 vabstol=1e-9 iabstol=1e-15
saveOptions options save=selected
parameters vdtest=0
VDD (vdd 0) vsource dc=1.8
IREF (vdd iref) isource dc=50u
VCM (cma 0) vsource dc=.95
VD (vd 0) vsource dc=vdtest mag=1
EINP (vinp cma vd 0) vcvs gain=.5
EINN (vinn cma vd 0) vcvs gain=-.5
X (0 iref vdd vinp vinn voutp voutn) cgm_amp
CLP (voutp 0) capacitor c=500f
CLN (voutn 0) capacitor c=500f
save vdd iref cma vd vinp vinn voutp voutn VDD:p X.nb X.nc X.rb2 X.tail
save X.MREF:ids X.MREF:gm X.MREF:gmbs X.MREF:gds X.MREF:vgs X.MREF:vds X.MREF:vdsat X.MREF:region
save X.MST:ids X.MST:gm X.MST:gmbs X.MST:gds X.MST:vgs X.MST:vds X.MST:vdsat X.MST:region
save X.MB1:ids X.MB1:gm X.MB1:gmbs X.MB1:gds X.MB1:vgs X.MB1:vds X.MB1:vdsat X.MB1:region
save X.MB2:ids X.MB2:gm X.MB2:gmbs X.MB2:gds X.MB2:vgs X.MB2:vds X.MB2:vdsat X.MB2:region
save X.MP1:ids X.MP1:gm X.MP1:gmbs X.MP1:gds X.MP1:vgs X.MP1:vds X.MP1:vdsat X.MP1:region
save X.MP2:ids X.MP2:gm X.MP2:gmbs X.MP2:gds X.MP2:vgs X.MP2:vds X.MP2:vdsat X.MP2:region
save X.MTAIL:ids X.MTAIL:gm X.MTAIL:gmbs X.MTAIL:gds X.MTAIL:vgs X.MTAIL:vds X.MTAIL:vdsat X.MTAIL:region
save X.MINP:ids X.MINP:gm X.MINP:gmbs X.MINP:gds X.MINP:vgs X.MINP:vds X.MINP:vdsat X.MINP:region
save X.MINN:ids X.MINN:gm X.MINN:gmbs X.MINN:gds X.MINN:vgs X.MINN:vds X.MINN:vdsat X.MINN:region
dcOp dc
ac ac start=10k stop=2G dec=100
linearity dc param=vdtest start=-.06 stop=.06 step=.002
