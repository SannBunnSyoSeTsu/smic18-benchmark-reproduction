simulator lang=spectre
global 0
include "/home/IC/Tech/smic_018mmrf-OA/SMIC_018_MMRF/models/spectre/ms018_v1p7_spe.lib" section=tt
include "/home/IC/CodeX/smic18_benchmark_repro/runs/13/20260922T072020597713Z_startup/inputs/circuit.scs"
simulatorOptions options temp=27 tnom=27 reltol=1e-6 vabstol=1e-9 iabstol=1e-15
saveOptions options save=selected
VDD (vdd 0) vsource type=pwl wave=[0 0 .1u 0 1.1u 1.8 20u 1.8]
IREF (vdd iref) isource type=pwl wave=[0 0 1.2u 0 1.22u 50u 20u 50u]
VCM (cma 0) vsource type=pwl wave=[0 0 .1u 0 1.1u .95 20u .95]
VD (vd 0) vsource type=pwl wave=[0 0 10u 0 10.02u .02 20u .02]
EINP (vinp cma vd 0) vcvs gain=.5
EINN (vinn cma vd 0) vcvs gain=-.5
X (0 iref vdd vinp vinn voutp voutn) cgm_amp
CLP (voutp 0) capacitor c=500f
CLN (voutn 0) capacitor c=500f
save vdd iref cma vd vinp vinn voutp voutn VDD:p X.nb X.nc X.rb2 X.tail
ic vdd=0 iref=0 cma=0 vd=0 vinp=0 vinn=0 voutp=0 voutn=0 X.nb=0 X.nc=0 X.rb2=0 X.tail=0
tran tran stop=20u maxstep=2n strobeperiod=2n strobeoutput=strobeonly skipdc=yes errpreset=conservative
