simulator lang=spectre
global 0
include "/home/IC/Tech/smic_018mmrf-OA/SMIC_018_MMRF/models/spectre/ms018_v1p7_spe.lib" section=tt
include "/home/IC/CodeX/smic18_benchmark_repro/runs/10/20260922T103416916168Z_ac/inputs/circuit.scs"
simulatorOptions options temp=27 tnom=27 reltol=1e-7 vabstol=1e-10 iabstol=1e-16
saveOptions options save=selected
VDD (vdd 0) vsource dc=1.8
IREF (vdd iref) isource dc=20u
VCM (vcm 0) vsource dc=.9
X (iref in vcm vdd vout 0) tia
CIN (in 0) capacitor c=.3p
CL (vout 0) capacitor c=.2p
save vout in vcm VDD:p VCM:p iref X.n1 X.nbuf
IIN (in 0) isource dc=0 mag=1
save X.MN1:ids X.MN1:gm X.MN1:gds X.MN1:vgs X.MN1:vds X.MN1:vdsat X.MN1:region
save X.MP1:ids X.MP1:gm X.MP1:gds X.MP1:vgs X.MP1:vds X.MP1:vdsat X.MP1:region
save X.MN2:ids X.MN2:gm X.MN2:gds X.MN2:vgs X.MN2:vds X.MN2:vdsat X.MN2:region
save X.MP2:ids X.MP2:gm X.MP2:gds X.MP2:vgs X.MP2:vds X.MP2:vdsat X.MP2:region
save X.MREF:ids X.MREF:gm X.MREF:gds X.MREF:vgs X.MREF:vds X.MREF:vdsat X.MREF:region
dcOp dc
ac ac start=1M stop=10.1G dec=100
